* NGSPICE file created from control_systolic.ext - technology: sky130A

* Black-box entry subcircuit for sky130_fd_sc_hd__fill_1 abstract view
.subckt sky130_fd_sc_hd__fill_1 VGND VNB VPB VPWR
.ends

* Black-box entry subcircuit for sky130_ef_sc_hd__decap_12 abstract view
.subckt sky130_ef_sc_hd__decap_12 VPWR VGND VPB VNB
.ends

* Black-box entry subcircuit for sky130_fd_sc_hd__xnor2_1 abstract view
.subckt sky130_fd_sc_hd__xnor2_1 A B VGND VNB VPB VPWR Y
.ends

* Black-box entry subcircuit for sky130_fd_sc_hd__decap_8 abstract view
.subckt sky130_fd_sc_hd__decap_8 VGND VNB VPB VPWR
.ends

* Black-box entry subcircuit for sky130_fd_sc_hd__and3_1 abstract view
.subckt sky130_fd_sc_hd__and3_1 A B C VGND VNB VPB VPWR X
.ends

* Black-box entry subcircuit for sky130_fd_sc_hd__decap_4 abstract view
.subckt sky130_fd_sc_hd__decap_4 VGND VNB VPB VPWR
.ends

* Black-box entry subcircuit for sky130_fd_sc_hd__a21o_1 abstract view
.subckt sky130_fd_sc_hd__a21o_1 A1 A2 B1 VGND VNB VPB VPWR X
.ends

* Black-box entry subcircuit for sky130_fd_sc_hd__xnor2_2 abstract view
.subckt sky130_fd_sc_hd__xnor2_2 A B VGND VNB VPB VPWR Y
.ends

* Black-box entry subcircuit for sky130_fd_sc_hd__tapvpwrvgnd_1 abstract view
.subckt sky130_fd_sc_hd__tapvpwrvgnd_1 VGND VPWR
.ends

* Black-box entry subcircuit for sky130_fd_sc_hd__decap_3 abstract view
.subckt sky130_fd_sc_hd__decap_3 VGND VNB VPB VPWR
.ends

* Black-box entry subcircuit for sky130_fd_sc_hd__fill_2 abstract view
.subckt sky130_fd_sc_hd__fill_2 VGND VNB VPB VPWR
.ends

* Black-box entry subcircuit for sky130_fd_sc_hd__decap_6 abstract view
.subckt sky130_fd_sc_hd__decap_6 VGND VNB VPB VPWR
.ends

* Black-box entry subcircuit for sky130_fd_sc_hd__nor2_1 abstract view
.subckt sky130_fd_sc_hd__nor2_1 A B VGND VNB VPB VPWR Y
.ends

* Black-box entry subcircuit for sky130_fd_sc_hd__nand2_1 abstract view
.subckt sky130_fd_sc_hd__nand2_1 A B VGND VNB VPB VPWR Y
.ends

* Black-box entry subcircuit for sky130_fd_sc_hd__dfrtp_1 abstract view
.subckt sky130_fd_sc_hd__dfrtp_1 CLK D RESET_B VGND VNB VPB VPWR Q
.ends

* Black-box entry subcircuit for sky130_fd_sc_hd__a22o_1 abstract view
.subckt sky130_fd_sc_hd__a22o_1 A1 A2 B1 B2 VGND VNB VPB VPWR X
.ends

* Black-box entry subcircuit for sky130_fd_sc_hd__buf_2 abstract view
.subckt sky130_fd_sc_hd__buf_2 A VGND VNB VPB VPWR X
.ends

* Black-box entry subcircuit for sky130_fd_sc_hd__clkbuf_2 abstract view
.subckt sky130_fd_sc_hd__clkbuf_2 A VGND VNB VPB VPWR X
.ends

* Black-box entry subcircuit for sky130_fd_sc_hd__clkbuf_4 abstract view
.subckt sky130_fd_sc_hd__clkbuf_4 A VGND VNB VPB VPWR X
.ends

* Black-box entry subcircuit for sky130_fd_sc_hd__inv_2 abstract view
.subckt sky130_fd_sc_hd__inv_2 A VGND VNB VPB VPWR Y
.ends

* Black-box entry subcircuit for sky130_fd_sc_hd__a21oi_1 abstract view
.subckt sky130_fd_sc_hd__a21oi_1 A1 A2 B1 VGND VNB VPB VPWR Y
.ends

* Black-box entry subcircuit for sky130_fd_sc_hd__o21a_1 abstract view
.subckt sky130_fd_sc_hd__o21a_1 A1 A2 B1 VGND VNB VPB VPWR X
.ends

* Black-box entry subcircuit for sky130_fd_sc_hd__a211oi_1 abstract view
.subckt sky130_fd_sc_hd__a211oi_1 A1 A2 B1 C1 VGND VNB VPB VPWR Y
.ends

* Black-box entry subcircuit for sky130_fd_sc_hd__or3_4 abstract view
.subckt sky130_fd_sc_hd__or3_4 A B C VGND VNB VPB VPWR X
.ends

* Black-box entry subcircuit for sky130_fd_sc_hd__xor2_1 abstract view
.subckt sky130_fd_sc_hd__xor2_1 A B VGND VNB VPB VPWR X
.ends

* Black-box entry subcircuit for sky130_fd_sc_hd__or2_1 abstract view
.subckt sky130_fd_sc_hd__or2_1 A B VGND VNB VPB VPWR X
.ends

* Black-box entry subcircuit for sky130_fd_sc_hd__o221ai_4 abstract view
.subckt sky130_fd_sc_hd__o221ai_4 A1 A2 B1 B2 C1 VGND VNB VPB VPWR Y
.ends

* Black-box entry subcircuit for sky130_fd_sc_hd__a2bb2o_1 abstract view
.subckt sky130_fd_sc_hd__a2bb2o_1 A1_N A2_N B1 B2 VGND VNB VPB VPWR X
.ends

* Black-box entry subcircuit for sky130_fd_sc_hd__a21bo_1 abstract view
.subckt sky130_fd_sc_hd__a21bo_1 A1 A2 B1_N VGND VNB VPB VPWR X
.ends

* Black-box entry subcircuit for sky130_fd_sc_hd__a22oi_2 abstract view
.subckt sky130_fd_sc_hd__a22oi_2 A1 A2 B1 B2 VGND VNB VPB VPWR Y
.ends

* Black-box entry subcircuit for sky130_fd_sc_hd__a21boi_1 abstract view
.subckt sky130_fd_sc_hd__a21boi_1 A1 A2 B1_N VGND VNB VPB VPWR Y
.ends

* Black-box entry subcircuit for sky130_fd_sc_hd__nand2b_1 abstract view
.subckt sky130_fd_sc_hd__nand2b_1 A_N B VGND VNB VPB VPWR Y
.ends

* Black-box entry subcircuit for sky130_fd_sc_hd__a221o_1 abstract view
.subckt sky130_fd_sc_hd__a221o_1 A1 A2 B1 B2 C1 VGND VNB VPB VPWR X
.ends

* Black-box entry subcircuit for sky130_fd_sc_hd__nand3_1 abstract view
.subckt sky130_fd_sc_hd__nand3_1 A B C VGND VNB VPB VPWR Y
.ends

* Black-box entry subcircuit for sky130_fd_sc_hd__mux2_1 abstract view
.subckt sky130_fd_sc_hd__mux2_1 A0 A1 S VGND VNB VPB VPWR X
.ends

* Black-box entry subcircuit for sky130_fd_sc_hd__and2_1 abstract view
.subckt sky130_fd_sc_hd__and2_1 A B VGND VNB VPB VPWR X
.ends

* Black-box entry subcircuit for sky130_fd_sc_hd__dlygate4sd3_1 abstract view
.subckt sky130_fd_sc_hd__dlygate4sd3_1 A VGND VNB VPB VPWR X
.ends

* Black-box entry subcircuit for sky130_fd_sc_hd__diode_2 abstract view
.subckt sky130_fd_sc_hd__diode_2 DIODE VGND VNB VPB VPWR
.ends

* Black-box entry subcircuit for sky130_fd_sc_hd__nand3_2 abstract view
.subckt sky130_fd_sc_hd__nand3_2 A B C VGND VNB VPB VPWR Y
.ends

* Black-box entry subcircuit for sky130_fd_sc_hd__o21ai_2 abstract view
.subckt sky130_fd_sc_hd__o21ai_2 A1 A2 B1 VGND VNB VPB VPWR Y
.ends

* Black-box entry subcircuit for sky130_fd_sc_hd__a31o_1 abstract view
.subckt sky130_fd_sc_hd__a31o_1 A1 A2 A3 B1 VGND VNB VPB VPWR X
.ends

* Black-box entry subcircuit for sky130_fd_sc_hd__dlymetal6s2s_1 abstract view
.subckt sky130_fd_sc_hd__dlymetal6s2s_1 A VGND VNB VPB VPWR X
.ends

* Black-box entry subcircuit for sky130_fd_sc_hd__nor3_1 abstract view
.subckt sky130_fd_sc_hd__nor3_1 A B C VGND VNB VPB VPWR Y
.ends

* Black-box entry subcircuit for sky130_fd_sc_hd__o211a_1 abstract view
.subckt sky130_fd_sc_hd__o211a_1 A1 A2 B1 C1 VGND VNB VPB VPWR X
.ends

* Black-box entry subcircuit for sky130_fd_sc_hd__a32o_1 abstract view
.subckt sky130_fd_sc_hd__a32o_1 A1 A2 A3 B1 B2 VGND VNB VPB VPWR X
.ends

* Black-box entry subcircuit for sky130_fd_sc_hd__or3_1 abstract view
.subckt sky130_fd_sc_hd__or3_1 A B C VGND VNB VPB VPWR X
.ends

* Black-box entry subcircuit for sky130_fd_sc_hd__xor2_2 abstract view
.subckt sky130_fd_sc_hd__xor2_2 A B VGND VNB VPB VPWR X
.ends

* Black-box entry subcircuit for sky130_fd_sc_hd__a211o_1 abstract view
.subckt sky130_fd_sc_hd__a211o_1 A1 A2 B1 C1 VGND VNB VPB VPWR X
.ends

* Black-box entry subcircuit for sky130_fd_sc_hd__nand4_1 abstract view
.subckt sky130_fd_sc_hd__nand4_1 A B C D VGND VNB VPB VPWR Y
.ends

* Black-box entry subcircuit for sky130_fd_sc_hd__and4_1 abstract view
.subckt sky130_fd_sc_hd__and4_1 A B C D VGND VNB VPB VPWR X
.ends

* Black-box entry subcircuit for sky130_fd_sc_hd__and4bb_1 abstract view
.subckt sky130_fd_sc_hd__and4bb_1 A_N B_N C D VGND VNB VPB VPWR X
.ends

* Black-box entry subcircuit for sky130_fd_sc_hd__and2b_1 abstract view
.subckt sky130_fd_sc_hd__and2b_1 A_N B VGND VNB VPB VPWR X
.ends

* Black-box entry subcircuit for sky130_fd_sc_hd__a22oi_1 abstract view
.subckt sky130_fd_sc_hd__a22oi_1 A1 A2 B1 B2 VGND VNB VPB VPWR Y
.ends

* Black-box entry subcircuit for sky130_fd_sc_hd__o2bb2a_1 abstract view
.subckt sky130_fd_sc_hd__o2bb2a_1 A1_N A2_N B1 B2 VGND VNB VPB VPWR X
.ends

* Black-box entry subcircuit for sky130_fd_sc_hd__a32oi_4 abstract view
.subckt sky130_fd_sc_hd__a32oi_4 A1 A2 A3 B1 B2 VGND VNB VPB VPWR Y
.ends

* Black-box entry subcircuit for sky130_fd_sc_hd__o21ai_1 abstract view
.subckt sky130_fd_sc_hd__o21ai_1 A1 A2 B1 VGND VNB VPB VPWR Y
.ends

* Black-box entry subcircuit for sky130_fd_sc_hd__nor2_4 abstract view
.subckt sky130_fd_sc_hd__nor2_4 A B VGND VNB VPB VPWR Y
.ends

* Black-box entry subcircuit for sky130_fd_sc_hd__o31a_1 abstract view
.subckt sky130_fd_sc_hd__o31a_1 A1 A2 A3 B1 VGND VNB VPB VPWR X
.ends

* Black-box entry subcircuit for sky130_fd_sc_hd__clkbuf_8 abstract view
.subckt sky130_fd_sc_hd__clkbuf_8 A VGND VNB VPB VPWR X
.ends

* Black-box entry subcircuit for sky130_fd_sc_hd__o211ai_2 abstract view
.subckt sky130_fd_sc_hd__o211ai_2 A1 A2 B1 C1 VGND VNB VPB VPWR Y
.ends

* Black-box entry subcircuit for sky130_fd_sc_hd__nand4_2 abstract view
.subckt sky130_fd_sc_hd__nand4_2 A B C D VGND VNB VPB VPWR Y
.ends

* Black-box entry subcircuit for sky130_fd_sc_hd__or4_4 abstract view
.subckt sky130_fd_sc_hd__or4_4 A B C D VGND VNB VPB VPWR X
.ends

* Black-box entry subcircuit for sky130_fd_sc_hd__o21ba_1 abstract view
.subckt sky130_fd_sc_hd__o21ba_1 A1 A2 B1_N VGND VNB VPB VPWR X
.ends

* Black-box entry subcircuit for sky130_fd_sc_hd__nor3b_2 abstract view
.subckt sky130_fd_sc_hd__nor3b_2 A B C_N VGND VNB VPB VPWR Y
.ends

* Black-box entry subcircuit for sky130_fd_sc_hd__and4b_1 abstract view
.subckt sky130_fd_sc_hd__and4b_1 A_N B C D VGND VNB VPB VPWR X
.ends

* Black-box entry subcircuit for sky130_fd_sc_hd__a31oi_1 abstract view
.subckt sky130_fd_sc_hd__a31oi_1 A1 A2 A3 B1 VGND VNB VPB VPWR Y
.ends

* Black-box entry subcircuit for sky130_fd_sc_hd__and3b_1 abstract view
.subckt sky130_fd_sc_hd__and3b_1 A_N B C VGND VNB VPB VPWR X
.ends

* Black-box entry subcircuit for sky130_fd_sc_hd__o221a_1 abstract view
.subckt sky130_fd_sc_hd__o221a_1 A1 A2 B1 B2 C1 VGND VNB VPB VPWR X
.ends

* Black-box entry subcircuit for sky130_fd_sc_hd__o21bai_1 abstract view
.subckt sky130_fd_sc_hd__o21bai_1 A1 A2 B1_N VGND VNB VPB VPWR Y
.ends

* Black-box entry subcircuit for sky130_fd_sc_hd__a21oi_2 abstract view
.subckt sky130_fd_sc_hd__a21oi_2 A1 A2 B1 VGND VNB VPB VPWR Y
.ends

* Black-box entry subcircuit for sky130_fd_sc_hd__inv_6 abstract view
.subckt sky130_fd_sc_hd__inv_6 A VGND VNB VPB VPWR Y
.ends

* Black-box entry subcircuit for sky130_fd_sc_hd__buf_4 abstract view
.subckt sky130_fd_sc_hd__buf_4 A VGND VNB VPB VPWR X
.ends

* Black-box entry subcircuit for sky130_fd_sc_hd__nand3b_2 abstract view
.subckt sky130_fd_sc_hd__nand3b_2 A_N B C VGND VNB VPB VPWR Y
.ends

* Black-box entry subcircuit for sky130_fd_sc_hd__clkinvlp_4 abstract view
.subckt sky130_fd_sc_hd__clkinvlp_4 A VGND VNB VPB VPWR Y
.ends

* Black-box entry subcircuit for sky130_fd_sc_hd__and2_2 abstract view
.subckt sky130_fd_sc_hd__and2_2 A B VGND VNB VPB VPWR X
.ends

* Black-box entry subcircuit for sky130_fd_sc_hd__clkbuf_16 abstract view
.subckt sky130_fd_sc_hd__clkbuf_16 A VGND VNB VPB VPWR X
.ends

* Black-box entry subcircuit for sky130_fd_sc_hd__dfrtp_2 abstract view
.subckt sky130_fd_sc_hd__dfrtp_2 CLK D RESET_B VGND VNB VPB VPWR Q
.ends

* Black-box entry subcircuit for sky130_fd_sc_hd__o22a_1 abstract view
.subckt sky130_fd_sc_hd__o22a_1 A1 A2 B1 B2 VGND VNB VPB VPWR X
.ends

* Black-box entry subcircuit for sky130_fd_sc_hd__clkinv_8 abstract view
.subckt sky130_fd_sc_hd__clkinv_8 A VGND VNB VPB VPWR Y
.ends

* Black-box entry subcircuit for sky130_fd_sc_hd__o211ai_1 abstract view
.subckt sky130_fd_sc_hd__o211ai_1 A1 A2 B1 C1 VGND VNB VPB VPWR Y
.ends

* Black-box entry subcircuit for sky130_fd_sc_hd__mux2_2 abstract view
.subckt sky130_fd_sc_hd__mux2_2 A0 A1 S VGND VNB VPB VPWR X
.ends

* Black-box entry subcircuit for sky130_fd_sc_hd__inv_4 abstract view
.subckt sky130_fd_sc_hd__inv_4 A VGND VNB VPB VPWR Y
.ends

* Black-box entry subcircuit for sky130_fd_sc_hd__a41o_1 abstract view
.subckt sky130_fd_sc_hd__a41o_1 A1 A2 A3 A4 B1 VGND VNB VPB VPWR X
.ends

* Black-box entry subcircuit for sky130_fd_sc_hd__dfxtp_1 abstract view
.subckt sky130_fd_sc_hd__dfxtp_1 CLK D VGND VNB VPB VPWR Q
.ends

* Black-box entry subcircuit for sky130_fd_sc_hd__clkinv_2 abstract view
.subckt sky130_fd_sc_hd__clkinv_2 A VGND VNB VPB VPWR Y
.ends

* Black-box entry subcircuit for sky130_fd_sc_hd__dfrtp_4 abstract view
.subckt sky130_fd_sc_hd__dfrtp_4 CLK D RESET_B VGND VNB VPB VPWR Q
.ends

* Black-box entry subcircuit for sky130_fd_sc_hd__clkbuf_1 abstract view
.subckt sky130_fd_sc_hd__clkbuf_1 A VGND VNB VPB VPWR X
.ends

* Black-box entry subcircuit for sky130_fd_sc_hd__or2_4 abstract view
.subckt sky130_fd_sc_hd__or2_4 A B VGND VNB VPB VPWR X
.ends

* Black-box entry subcircuit for sky130_fd_sc_hd__mux2_4 abstract view
.subckt sky130_fd_sc_hd__mux2_4 A0 A1 S VGND VNB VPB VPWR X
.ends

* Black-box entry subcircuit for sky130_fd_sc_hd__clkinv_4 abstract view
.subckt sky130_fd_sc_hd__clkinv_4 A VGND VNB VPB VPWR Y
.ends

* Black-box entry subcircuit for sky130_fd_sc_hd__bufinv_16 abstract view
.subckt sky130_fd_sc_hd__bufinv_16 A VGND VNB VPB VPWR Y
.ends

* Black-box entry subcircuit for sky130_fd_sc_hd__a211oi_2 abstract view
.subckt sky130_fd_sc_hd__a211oi_2 A1 A2 B1 C1 VGND VNB VPB VPWR Y
.ends

* Black-box entry subcircuit for sky130_fd_sc_hd__nor4_1 abstract view
.subckt sky130_fd_sc_hd__nor4_1 A B C D VGND VNB VPB VPWR Y
.ends

* Black-box entry subcircuit for sky130_fd_sc_hd__and3_4 abstract view
.subckt sky130_fd_sc_hd__and3_4 A B C VGND VNB VPB VPWR X
.ends

* Black-box entry subcircuit for sky130_fd_sc_hd__o31ai_2 abstract view
.subckt sky130_fd_sc_hd__o31ai_2 A1 A2 A3 B1 VGND VNB VPB VPWR Y
.ends

* Black-box entry subcircuit for sky130_fd_sc_hd__inv_8 abstract view
.subckt sky130_fd_sc_hd__inv_8 A VGND VNB VPB VPWR Y
.ends

* Black-box entry subcircuit for sky130_fd_sc_hd__buf_1 abstract view
.subckt sky130_fd_sc_hd__buf_1 A VGND VNB VPB VPWR X
.ends

* Black-box entry subcircuit for sky130_fd_sc_hd__a2111o_1 abstract view
.subckt sky130_fd_sc_hd__a2111o_1 A1 A2 B1 C1 D1 VGND VNB VPB VPWR X
.ends

* Black-box entry subcircuit for sky130_fd_sc_hd__nor3_2 abstract view
.subckt sky130_fd_sc_hd__nor3_2 A B C VGND VNB VPB VPWR Y
.ends

* Black-box entry subcircuit for sky130_fd_sc_hd__or3b_1 abstract view
.subckt sky130_fd_sc_hd__or3b_1 A B C_N VGND VNB VPB VPWR X
.ends

* Black-box entry subcircuit for sky130_fd_sc_hd__o32a_1 abstract view
.subckt sky130_fd_sc_hd__o32a_1 A1 A2 A3 B1 B2 VGND VNB VPB VPWR X
.ends

* Black-box entry subcircuit for sky130_fd_sc_hd__or4b_4 abstract view
.subckt sky130_fd_sc_hd__or4b_4 A B C D_N VGND VNB VPB VPWR X
.ends

* Black-box entry subcircuit for sky130_fd_sc_hd__and3_2 abstract view
.subckt sky130_fd_sc_hd__and3_2 A B C VGND VNB VPB VPWR X
.ends

* Black-box entry subcircuit for sky130_fd_sc_hd__or3b_4 abstract view
.subckt sky130_fd_sc_hd__or3b_4 A B C_N VGND VNB VPB VPWR X
.ends

* Black-box entry subcircuit for sky130_fd_sc_hd__nor3b_1 abstract view
.subckt sky130_fd_sc_hd__nor3b_1 A B C_N VGND VNB VPB VPWR Y
.ends

* Black-box entry subcircuit for sky130_fd_sc_hd__nand3b_1 abstract view
.subckt sky130_fd_sc_hd__nand3b_1 A_N B C VGND VNB VPB VPWR Y
.ends

* Black-box entry subcircuit for sky130_fd_sc_hd__a41o_2 abstract view
.subckt sky130_fd_sc_hd__a41o_2 A1 A2 A3 A4 B1 VGND VNB VPB VPWR X
.ends

* Black-box entry subcircuit for sky130_fd_sc_hd__nor2_2 abstract view
.subckt sky130_fd_sc_hd__nor2_2 A B VGND VNB VPB VPWR Y
.ends

* Black-box entry subcircuit for sky130_fd_sc_hd__o311a_4 abstract view
.subckt sky130_fd_sc_hd__o311a_4 A1 A2 A3 B1 C1 VGND VNB VPB VPWR X
.ends

* Black-box entry subcircuit for sky130_fd_sc_hd__nand3_4 abstract view
.subckt sky130_fd_sc_hd__nand3_4 A B C VGND VNB VPB VPWR Y
.ends

* Black-box entry subcircuit for sky130_fd_sc_hd__a21boi_2 abstract view
.subckt sky130_fd_sc_hd__a21boi_2 A1 A2 B1_N VGND VNB VPB VPWR Y
.ends

* Black-box entry subcircuit for sky130_fd_sc_hd__buf_8 abstract view
.subckt sky130_fd_sc_hd__buf_8 A VGND VNB VPB VPWR X
.ends

* Black-box entry subcircuit for sky130_fd_sc_hd__o22ai_1 abstract view
.subckt sky130_fd_sc_hd__o22ai_1 A1 A2 B1 B2 VGND VNB VPB VPWR Y
.ends

* Black-box entry subcircuit for sky130_fd_sc_hd__dlygate4sd1_1 abstract view
.subckt sky130_fd_sc_hd__dlygate4sd1_1 A VGND VNB VPB VPWR X
.ends

* Black-box entry subcircuit for sky130_fd_sc_hd__buf_6 abstract view
.subckt sky130_fd_sc_hd__buf_6 A VGND VNB VPB VPWR X
.ends

* Black-box entry subcircuit for sky130_fd_sc_hd__buf_12 abstract view
.subckt sky130_fd_sc_hd__buf_12 A VGND VNB VPB VPWR X
.ends

* Black-box entry subcircuit for sky130_fd_sc_hd__a21oi_4 abstract view
.subckt sky130_fd_sc_hd__a21oi_4 A1 A2 B1 VGND VNB VPB VPWR Y
.ends

.subckt control_systolic D_a_00[0] D_a_00[1] D_a_00[2] D_a_00[3] D_a_00[4] D_a_00[5]
+ D_a_00[6] D_a_00[7] D_a_10[0] D_a_10[1] D_a_10[2] D_a_10[3] D_a_10[4] D_a_10[5]
+ D_a_10[6] D_a_10[7] D_b_00[0] D_b_00[1] D_b_00[2] D_b_00[3] D_b_00[4] D_b_00[5]
+ D_b_00[6] D_b_00[7] D_b_01[0] D_b_01[1] D_b_01[2] D_b_01[3] D_b_01[4] D_b_01[5]
+ D_b_01[6] D_b_01[7] D_c_flat[0] D_c_flat[10] D_c_flat[11] D_c_flat[12] D_c_flat[13]
+ D_c_flat[14] D_c_flat[15] D_c_flat[16] D_c_flat[17] D_c_flat[18] D_c_flat[19] D_c_flat[1]
+ D_c_flat[20] D_c_flat[21] D_c_flat[22] D_c_flat[23] D_c_flat[24] D_c_flat[25] D_c_flat[26]
+ D_c_flat[27] D_c_flat[28] D_c_flat[29] D_c_flat[2] D_c_flat[30] D_c_flat[31] D_c_flat[3]
+ D_c_flat[4] D_c_flat[5] D_c_flat[6] D_c_flat[7] D_c_flat[8] D_c_flat[9] VGND VPWR
+ a_ready b_ready clk num_matrix[0] num_matrix[1] num_matrix[2] rst systolic_busy
+ systolic_free
XFILLER_67_553 VGND VGND VPWR VPWR sky130_fd_sc_hd__fill_1
XFILLER_82_501 VPWR VGND VPWR VGND sky130_ef_sc_hd__decap_12
X_3155_ _1074_ _1075_ VGND VGND VPWR VPWR _1076_ sky130_fd_sc_hd__xnor2_1
XFILLER_27_417 VPWR VGND VPWR VGND sky130_ef_sc_hd__decap_12
XFILLER_39_255 VPWR VGND VPWR VGND sky130_ef_sc_hd__decap_12
XFILLER_82_545 VGND VGND VPWR VPWR sky130_fd_sc_hd__decap_8
X_3086_ _0993_ _1001_ _1005_ VGND VGND VPWR VPWR _1007_ sky130_fd_sc_hd__and3_1
XFILLER_54_247 VGND VGND VPWR VPWR sky130_fd_sc_hd__decap_4
XFILLER_35_483 VGND VGND VPWR VPWR sky130_fd_sc_hd__decap_8
XFILLER_22_111 VGND VGND VPWR VPWR sky130_fd_sc_hd__decap_8
X_3988_ _1746_ _1825_ net145 VGND VGND VPWR VPWR _1846_ sky130_fd_sc_hd__a21o_1
X_2939_ _0882_ _0888_ VGND VGND VPWR VPWR _0892_ sky130_fd_sc_hd__xnor2_2
XFILLER_10_339 VPWR VGND VPWR VGND sky130_ef_sc_hd__decap_12
XTAP_TAPCELL_ROW_20_389 VGND VPWR sky130_fd_sc_hd__tapvpwrvgnd_1
XFILLER_89_111 VGND VGND VPWR VPWR sky130_fd_sc_hd__fill_1
XFILLER_92_309 VPWR VGND VPWR VGND sky130_ef_sc_hd__decap_12
XFILLER_85_361 VPWR VGND VPWR VGND sky130_ef_sc_hd__decap_12
XFILLER_73_501 VGND VGND VPWR VPWR sky130_fd_sc_hd__decap_3
XFILLER_18_428 VGND VGND VPWR VPWR sky130_fd_sc_hd__fill_2
XTAP_TAPCELL_ROW_56_732 VGND VPWR sky130_fd_sc_hd__tapvpwrvgnd_1
XFILLER_93_69 VPWR VGND VPWR VGND sky130_ef_sc_hd__decap_12
XFILLER_26_41 VGND VGND VPWR VPWR sky130_fd_sc_hd__decap_8
XTAP_TAPCELL_ROW_28_467 VGND VPWR sky130_fd_sc_hd__tapvpwrvgnd_1
XFILLER_60_217 VPWR VGND VPWR VGND sky130_ef_sc_hd__decap_12
XFILLER_26_85 VGND VGND VPWR VPWR sky130_fd_sc_hd__decap_6
XFILLER_9_104 VGND VGND VPWR VPWR sky130_fd_sc_hd__decap_8
XFILLER_41_453 VGND VGND VPWR VPWR sky130_fd_sc_hd__fill_1
XFILLER_9_159 VGND VGND VPWR VPWR sky130_fd_sc_hd__fill_1
XFILLER_68_317 VGND VGND VPWR VPWR sky130_fd_sc_hd__fill_2
XFILLER_76_350 VPWR VGND VPWR VGND sky130_ef_sc_hd__decap_12
XFILLER_64_545 VGND VGND VPWR VPWR sky130_fd_sc_hd__decap_8
XFILLER_91_364 VGND VGND VPWR VPWR sky130_fd_sc_hd__fill_1
XFILLER_17_461 VGND VGND VPWR VPWR sky130_fd_sc_hd__fill_1
XFILLER_17_494 VGND VGND VPWR VPWR sky130_fd_sc_hd__decap_8
X_3911_ net148 _1795_ _1796_ VGND VGND VPWR VPWR _0285_ sky130_fd_sc_hd__a21o_1
X_3842_ net204 net186 _1730_ VGND VGND VPWR VPWR _1731_ sky130_fd_sc_hd__and3_1
X_3773_ _1658_ _1659_ VGND VGND VPWR VPWR _1662_ sky130_fd_sc_hd__xnor2_1
X_2724_ _0669_ _0670_ VGND VGND VPWR VPWR _0677_ sky130_fd_sc_hd__nor2_1
X_2655_ _0606_ _0607_ VGND VGND VPWR VPWR _0608_ sky130_fd_sc_hd__nand2_1
X_4325_ clknet_leaf_28_clk _0306_ _0049_ VGND VGND VPWR VPWR systolic_unit_0.U_10.acc_0\[1\]
+ sky130_fd_sc_hd__dfrtp_1
X_2586_ net370 net88 _0567_ net209 VGND VGND VPWR VPWR _0381_ sky130_fd_sc_hd__a22o_1
Xfanout127 systolic_unit_0.U_01.in_b\[2\] VGND VGND VPWR VPWR net127 sky130_fd_sc_hd__buf_2
Xfanout105 systolic_unit_0.U_10.in_a\[5\] VGND VGND VPWR VPWR net105 sky130_fd_sc_hd__buf_2
Xfanout116 systolic_unit_0.U_10.in_a\[0\] VGND VGND VPWR VPWR net116 sky130_fd_sc_hd__clkbuf_2
Xfanout138 net141 VGND VGND VPWR VPWR net138 sky130_fd_sc_hd__clkbuf_4
X_4256_ net237 VGND VGND VPWR VPWR _0237_ sky130_fd_sc_hd__inv_2
Xfanout149 net150 VGND VGND VPWR VPWR net149 sky130_fd_sc_hd__clkbuf_2
XFILLER_74_309 VPWR VGND VPWR VGND sky130_ef_sc_hd__decap_12
X_3207_ net115 net155 VGND VGND VPWR VPWR _1128_ sky130_fd_sc_hd__nand2_1
X_4187_ net228 VGND VGND VPWR VPWR _0168_ sky130_fd_sc_hd__inv_2
XFILLER_27_225 VGND VGND VPWR VPWR sky130_fd_sc_hd__decap_8
X_3138_ _1055_ _1057_ _1031_ VGND VGND VPWR VPWR _1059_ sky130_fd_sc_hd__a21oi_1
XFILLER_27_236 VPWR VGND VPWR VGND sky130_ef_sc_hd__decap_12
X_3069_ _0978_ _0979_ _0988_ VGND VGND VPWR VPWR _0990_ sky130_fd_sc_hd__o21a_1
XFILLER_42_217 VGND VGND VPWR VPWR sky130_fd_sc_hd__decap_4
XTAP_TAPCELL_ROW_53_702 VGND VPWR sky130_fd_sc_hd__tapvpwrvgnd_1
XTAP_TAPCELL_ROW_25_437 VGND VPWR sky130_fd_sc_hd__tapvpwrvgnd_1
XFILLER_10_147 VGND VGND VPWR VPWR sky130_fd_sc_hd__fill_1
XFILLER_77_125 VPWR VGND VPWR VGND sky130_ef_sc_hd__decap_12
XFILLER_77_169 VPWR VGND VPWR VGND sky130_ef_sc_hd__decap_12
XFILLER_92_139 VGND VGND VPWR VPWR sky130_fd_sc_hd__fill_1
XFILLER_37_40 VPWR VGND VPWR VGND sky130_ef_sc_hd__decap_12
XFILLER_73_375 VPWR VGND VPWR VGND sky130_ef_sc_hd__decap_12
XFILLER_61_548 VGND VGND VPWR VPWR sky130_fd_sc_hd__fill_2
XFILLER_14_497 VPWR VGND VPWR VGND sky130_ef_sc_hd__decap_12
XFILLER_14_475 VGND VGND VPWR VPWR sky130_fd_sc_hd__fill_1
X_2440_ _0423_ _0424_ VGND VGND VPWR VPWR _0425_ sky130_fd_sc_hd__nor2_1
XFILLER_5_195 VGND VGND VPWR VPWR sky130_fd_sc_hd__fill_1
X_2371_ _2027_ _2036_ _2053_ _2067_ VGND VGND VPWR VPWR _2070_ sky130_fd_sc_hd__a211oi_1
XFILLER_68_114 VPWR VGND VPWR VGND sky130_ef_sc_hd__decap_12
X_4110_ net244 VGND VGND VPWR VPWR _0091_ sky130_fd_sc_hd__inv_2
X_4041_ net242 VGND VGND VPWR VPWR _0022_ sky130_fd_sc_hd__inv_2
XTAP_TAPCELL_ROW_67_838 VGND VPWR sky130_fd_sc_hd__tapvpwrvgnd_1
XFILLER_64_331 VPWR VGND VPWR VGND sky130_ef_sc_hd__decap_12
XFILLER_91_161 VGND VGND VPWR VPWR sky130_fd_sc_hd__decap_6
XTAP_TAPCELL_ROW_22_407 VGND VPWR sky130_fd_sc_hd__tapvpwrvgnd_1
XFILLER_32_294 VGND VGND VPWR VPWR sky130_fd_sc_hd__decap_8
X_3825_ _1705_ _1708_ _1710_ VGND VGND VPWR VPWR _1714_ sky130_fd_sc_hd__or3_4
X_3756_ _1643_ _1644_ VGND VGND VPWR VPWR _1645_ sky130_fd_sc_hd__xor2_1
X_2707_ _0658_ _0659_ VGND VGND VPWR VPWR _0660_ sky130_fd_sc_hd__or2_1
XTAP_TAPCELL_ROW_30_484 VGND VPWR sky130_fd_sc_hd__tapvpwrvgnd_1
X_3687_ _1552_ _1553_ VGND VGND VPWR VPWR _1576_ sky130_fd_sc_hd__xnor2_1
X_2638_ systolic_unit_0.U_01.drain_0 net140 VGND VGND VPWR VPWR _0591_ sky130_fd_sc_hd__nor2_1
XFILLER_87_412 VPWR VGND VPWR VGND sky130_ef_sc_hd__decap_12
XFILLER_87_401 VGND VGND VPWR VPWR sky130_fd_sc_hd__fill_2
X_2569_ _0547_ _0550_ _0553_ _0538_ _0545_ VGND VGND VPWR VPWR _0554_ sky130_fd_sc_hd__o221ai_4
X_4308_ clknet_leaf_28_clk _0289_ _0032_ VGND VGND VPWR VPWR systolic_unit_0.U_10.acc_1\[0\]
+ sky130_fd_sc_hd__dfrtp_1
XFILLER_59_125 VPWR VGND VPWR VGND sky130_ef_sc_hd__decap_12
X_4239_ net223 VGND VGND VPWR VPWR _0220_ sky130_fd_sc_hd__inv_2
XFILLER_28_501 VGND VGND VPWR VPWR sky130_fd_sc_hd__decap_3
XFILLER_28_545 VGND VGND VPWR VPWR sky130_fd_sc_hd__decap_8
XFILLER_15_217 VGND VGND VPWR VPWR sky130_fd_sc_hd__decap_6
XTAP_TAPCELL_ROW_38_562 VGND VPWR sky130_fd_sc_hd__tapvpwrvgnd_1
XFILLER_82_183 VGND VGND VPWR VPWR sky130_fd_sc_hd__fill_1
XFILLER_90_15 VPWR VGND VPWR VGND sky130_ef_sc_hd__decap_12
XFILLER_70_389 VPWR VGND VPWR VGND sky130_ef_sc_hd__decap_12
XFILLER_7_405 VPWR VGND VPWR VGND sky130_ef_sc_hd__decap_12
XFILLER_7_449 VPWR VGND VPWR VGND sky130_ef_sc_hd__decap_12
XFILLER_2_121 VGND VGND VPWR VPWR sky130_fd_sc_hd__decap_8
XFILLER_2_187 VGND VGND VPWR VPWR sky130_fd_sc_hd__fill_2
XFILLER_78_456 VGND VGND VPWR VPWR sky130_fd_sc_hd__decap_6
XFILLER_48_83 VGND VGND VPWR VPWR sky130_fd_sc_hd__fill_1
XTAP_TAPCELL_ROW_64_808 VGND VPWR sky130_fd_sc_hd__tapvpwrvgnd_1
XFILLER_0_57 VPWR VGND VPWR VGND sky130_ef_sc_hd__decap_12
XFILLER_46_353 VGND VGND VPWR VPWR sky130_fd_sc_hd__fill_1
XTAP_TAPCELL_ROW_72_885 VGND VPWR sky130_fd_sc_hd__tapvpwrvgnd_1
XFILLER_9_77 VGND VGND VPWR VPWR sky130_fd_sc_hd__fill_1
XFILLER_9_55 VGND VGND VPWR VPWR sky130_fd_sc_hd__fill_1
X_3610_ _1478_ _1488_ VGND VGND VPWR VPWR _1499_ sky130_fd_sc_hd__xor2_1
X_3541_ net194 net179 VGND VGND VPWR VPWR _1430_ sky130_fd_sc_hd__nand2_1
X_3472_ _1326_ _1300_ _1285_ _1325_ VGND VGND VPWR VPWR _1383_ sky130_fd_sc_hd__a2bb2o_1
XFILLER_50_3 VGND VGND VPWR VPWR sky130_fd_sc_hd__decap_3
X_2423_ _2119_ _2120_ _2118_ VGND VGND VPWR VPWR _2122_ sky130_fd_sc_hd__a21bo_1
X_2354_ _2013_ _2037_ _2052_ VGND VGND VPWR VPWR _2053_ sky130_fd_sc_hd__and3_1
X_2285_ net263 net218 net216 net264 VGND VGND VPWR VPWR _1984_ sky130_fd_sc_hd__a22oi_2
X_4024_ net243 VGND VGND VPWR VPWR _0005_ sky130_fd_sc_hd__inv_2
XFILLER_56_139 VGND VGND VPWR VPWR sky130_fd_sc_hd__fill_1
XTAP_TAPCELL_ROW_35_532 VGND VPWR sky130_fd_sc_hd__tapvpwrvgnd_1
XFILLER_20_275 VGND VGND VPWR VPWR sky130_fd_sc_hd__fill_2
X_3808_ _1655_ _1669_ _1668_ VGND VGND VPWR VPWR _1697_ sky130_fd_sc_hd__o21a_1
XFILLER_4_419 VGND VGND VPWR VPWR sky130_fd_sc_hd__fill_1
X_3739_ _1626_ _1627_ _1621_ VGND VGND VPWR VPWR _1628_ sky130_fd_sc_hd__a21boi_1
XFILLER_87_253 VPWR VGND VPWR VGND sky130_ef_sc_hd__decap_12
XFILLER_85_15 VPWR VGND VPWR VGND sky130_ef_sc_hd__decap_12
XTAP_TAPCELL_ROW_7_268 VGND VPWR sky130_fd_sc_hd__tapvpwrvgnd_1
XFILLER_18_42 VGND VGND VPWR VPWR sky130_fd_sc_hd__fill_1
XFILLER_28_353 VGND VGND VPWR VPWR sky130_fd_sc_hd__decap_8
XFILLER_55_161 VGND VGND VPWR VPWR sky130_fd_sc_hd__decap_6
XFILLER_62_109 VGND VGND VPWR VPWR sky130_fd_sc_hd__decap_8
XFILLER_28_386 VPWR VGND VPWR VGND sky130_ef_sc_hd__decap_12
XFILLER_31_518 VPWR VGND VPWR VGND sky130_ef_sc_hd__decap_12
XFILLER_43_356 VGND VGND VPWR VPWR sky130_fd_sc_hd__fill_2
XFILLER_70_197 VPWR VGND VPWR VGND sky130_ef_sc_hd__decap_12
XFILLER_11_231 VGND VGND VPWR VPWR sky130_fd_sc_hd__fill_1
XFILLER_3_441 VGND VGND VPWR VPWR sky130_fd_sc_hd__decap_6
XFILLER_3_485 VPWR VGND VPWR VGND sky130_ef_sc_hd__decap_12
XFILLER_78_253 VPWR VGND VPWR VGND sky130_ef_sc_hd__decap_12
XTAP_TAPCELL_ROW_77_933 VGND VPWR sky130_fd_sc_hd__tapvpwrvgnd_1
XFILLER_66_415 VGND VGND VPWR VPWR sky130_fd_sc_hd__decap_4
XFILLER_93_223 VGND VGND VPWR VPWR sky130_fd_sc_hd__fill_1
XFILLER_38_139 VGND VGND VPWR VPWR sky130_fd_sc_hd__fill_1
XFILLER_19_364 VGND VGND VPWR VPWR sky130_fd_sc_hd__decap_8
XFILLER_46_150 VGND VGND VPWR VPWR sky130_fd_sc_hd__decap_8
XTAP_TAPCELL_ROW_49_668 VGND VPWR sky130_fd_sc_hd__tapvpwrvgnd_1
X_2972_ _0869_ _0924_ VGND VGND VPWR VPWR _0925_ sky130_fd_sc_hd__nand2b_1
XTAP_TAPCELL_ROW_32_502 VGND VPWR sky130_fd_sc_hd__tapvpwrvgnd_1
XFILLER_61_186 VPWR VGND VPWR VGND sky130_ef_sc_hd__decap_12
X_3524_ systolic_unit_0.U_10.acc_1\[4\] _1403_ _1405_ net410 _1417_ VGND VGND VPWR
+ VPWR _0293_ sky130_fd_sc_hd__a221o_1
XFILLER_89_529 VPWR VGND VPWR VGND sky130_ef_sc_hd__decap_12
X_3455_ net304 _1356_ _1369_ _1370_ VGND VGND VPWR VPWR _0315_ sky130_fd_sc_hd__a22o_1
X_2406_ _2102_ _2103_ _2104_ VGND VGND VPWR VPWR _2105_ sky130_fd_sc_hd__nand3_1
XFILLER_69_231 VGND VGND VPWR VPWR sky130_fd_sc_hd__decap_6
X_3386_ systolic_unit_0.U_10.acc_1\[1\] systolic_unit_0.U_10.acc_0\[1\] net137 VGND
+ VGND VPWR VPWR _1307_ sky130_fd_sc_hd__mux2_1
X_2337_ _2015_ _2026_ _2025_ VGND VGND VPWR VPWR _2036_ sky130_fd_sc_hd__a21o_1
XFILLER_69_275 VGND VGND VPWR VPWR sky130_fd_sc_hd__decap_4
XTAP_TAPCELL_ROW_4_238 VGND VPWR sky130_fd_sc_hd__tapvpwrvgnd_1
X_2268_ net268 net213 VGND VGND VPWR VPWR _1967_ sky130_fd_sc_hd__and2_1
XFILLER_57_437 VGND VGND VPWR VPWR sky130_fd_sc_hd__decap_3
X_4007_ matrix_count\[2\] net37 VGND VGND VPWR VPWR _1856_ sky130_fd_sc_hd__nand2_1
X_2199_ net334 _1899_ net91 VGND VGND VPWR VPWR _0386_ sky130_fd_sc_hd__mux2_1
XFILLER_71_28 VGND VGND VPWR VPWR sky130_fd_sc_hd__fill_1
XFILLER_13_529 VPWR VGND VPWR VGND sky130_ef_sc_hd__decap_12
XFILLER_25_389 VGND VGND VPWR VPWR sky130_fd_sc_hd__decap_3
XFILLER_52_197 VPWR VGND VPWR VGND sky130_ef_sc_hd__decap_12
XFILLER_0_433 VPWR VGND VPWR VGND sky130_ef_sc_hd__decap_12
XFILLER_0_477 VPWR VGND VPWR VGND sky130_ef_sc_hd__decap_12
Xhold41 systolic_unit_0.U_10.acc_0\[0\] VGND VGND VPWR VPWR net316 sky130_fd_sc_hd__dlygate4sd3_1
Xhold30 systolic_unit_0.U_10.acc_1\[12\] VGND VGND VPWR VPWR net305 sky130_fd_sc_hd__dlygate4sd3_1
Xhold63 net53 VGND VGND VPWR VPWR net338 sky130_fd_sc_hd__dlygate4sd3_1
Xhold52 drain_odd VGND VGND VPWR VPWR net327 sky130_fd_sc_hd__dlygate4sd3_1
Xhold74 net59 VGND VGND VPWR VPWR net349 sky130_fd_sc_hd__dlygate4sd3_1
XTAP_TAPCELL_ROW_74_903 VGND VPWR sky130_fd_sc_hd__tapvpwrvgnd_1
Xhold85 row_count\[1\] VGND VGND VPWR VPWR net360 sky130_fd_sc_hd__dlygate4sd3_1
Xhold96 systolic_unit_0.U_00.acc_0\[6\] VGND VGND VPWR VPWR net371 sky130_fd_sc_hd__dlygate4sd3_1
XFILLER_28_172 VPWR VGND VPWR VGND sky130_ef_sc_hd__decap_12
XTAP_TAPCELL_ROW_46_638 VGND VPWR sky130_fd_sc_hd__tapvpwrvgnd_1
XTAP_TAPCELL_ROW_82_980 VGND VPWR sky130_fd_sc_hd__tapvpwrvgnd_1
XFILLER_16_378 VGND VGND VPWR VPWR sky130_fd_sc_hd__fill_1
XFILLER_8_533 VPWR VGND VPWR VGND sky130_ef_sc_hd__decap_12
XANTENNA_5 systolic_unit_0.drain_valid VGND VGND VPWR VPWR sky130_fd_sc_hd__diode_2
XFILLER_3_293 VGND VGND VPWR VPWR sky130_fd_sc_hd__decap_6
X_3240_ _1125_ _1159_ VGND VGND VPWR VPWR _1161_ sky130_fd_sc_hd__xor2_1
X_3171_ net160 net103 VGND VGND VPWR VPWR _1092_ sky130_fd_sc_hd__nand2_1
XFILLER_39_415 VGND VGND VPWR VPWR sky130_fd_sc_hd__fill_2
XFILLER_13_3 VGND VGND VPWR VPWR sky130_fd_sc_hd__decap_8
XFILLER_39_459 VPWR VGND VPWR VGND sky130_ef_sc_hd__decap_12
XFILLER_66_212 VGND VGND VPWR VPWR sky130_fd_sc_hd__decap_4
XTAP_TAPCELL_ROW_1_208 VGND VPWR sky130_fd_sc_hd__tapvpwrvgnd_1
XFILLER_81_215 VGND VGND VPWR VPWR sky130_fd_sc_hd__decap_8
XFILLER_19_172 VPWR VGND VPWR VGND sky130_ef_sc_hd__decap_12
XFILLER_47_481 VGND VGND VPWR VPWR sky130_fd_sc_hd__decap_3
XTAP_TAPCELL_ROW_17_362 VGND VPWR sky130_fd_sc_hd__tapvpwrvgnd_1
XFILLER_22_304 VGND VGND VPWR VPWR sky130_fd_sc_hd__decap_4
XFILLER_22_359 VGND VGND VPWR VPWR sky130_fd_sc_hd__decap_4
XFILLER_34_197 VPWR VGND VPWR VGND sky130_ef_sc_hd__decap_12
X_2955_ _0902_ _0903_ VGND VGND VPWR VPWR _0908_ sky130_fd_sc_hd__xnor2_1
X_2886_ _0837_ _0838_ _0835_ VGND VGND VPWR VPWR _0839_ sky130_fd_sc_hd__o21a_1
X_3507_ net132 _1360_ VGND VGND VPWR VPWR _1409_ sky130_fd_sc_hd__nor2_1
XFILLER_89_315 VGND VGND VPWR VPWR sky130_fd_sc_hd__fill_2
X_4487_ clknet_leaf_25_clk net323 _0211_ VGND VGND VPWR VPWR systolic_unit_0.out_acc_0_r1\[2\]
+ sky130_fd_sc_hd__dfrtp_1
XFILLER_1_219 VGND VGND VPWR VPWR sky130_fd_sc_hd__decap_4
X_3438_ systolic_unit_0.U_10.acc_0\[13\] systolic_unit_0.U_00.acc_0\[13\] net206 VGND
+ VGND VPWR VPWR _1357_ sky130_fd_sc_hd__mux2_1
X_3369_ _1287_ _1288_ _1289_ VGND VGND VPWR VPWR _1290_ sky130_fd_sc_hd__nand3_2
XFILLER_57_267 VGND VGND VPWR VPWR sky130_fd_sc_hd__fill_1
XFILLER_38_470 VGND VGND VPWR VPWR sky130_fd_sc_hd__decap_6
XFILLER_82_27 VGND VGND VPWR VPWR sky130_fd_sc_hd__fill_1
XTAP_TAPCELL_ROW_43_608 VGND VPWR sky130_fd_sc_hd__tapvpwrvgnd_1
XFILLER_53_473 VGND VGND VPWR VPWR sky130_fd_sc_hd__decap_4
XFILLER_80_281 VGND VGND VPWR VPWR sky130_fd_sc_hd__decap_8
XFILLER_13_337 VPWR VGND VPWR VGND sky130_ef_sc_hd__decap_12
XFILLER_25_186 VGND VGND VPWR VPWR sky130_fd_sc_hd__fill_1
XFILLER_40_123 VPWR VGND VPWR VGND sky130_ef_sc_hd__decap_12
XTAP_TAPCELL_ROW_51_685 VGND VPWR sky130_fd_sc_hd__tapvpwrvgnd_1
XFILLER_5_503 VGND VGND VPWR VPWR sky130_fd_sc_hd__fill_1
XFILLER_31_53 VGND VGND VPWR VPWR sky130_fd_sc_hd__decap_3
Xoutput42 net42 VGND VGND VPWR VPWR D_c_flat[12] sky130_fd_sc_hd__buf_2
XTAP_TAPCELL_ROW_91_1069 VGND VPWR sky130_fd_sc_hd__tapvpwrvgnd_1
Xoutput64 net64 VGND VGND VPWR VPWR D_c_flat[3] sky130_fd_sc_hd__buf_2
Xoutput53 net53 VGND VGND VPWR VPWR D_c_flat[22] sky130_fd_sc_hd__buf_2
XTAP_TAPCELL_ROW_59_763 VGND VPWR sky130_fd_sc_hd__tapvpwrvgnd_1
XFILLER_56_83 VGND VGND VPWR VPWR sky130_fd_sc_hd__fill_1
XFILLER_16_175 VGND VGND VPWR VPWR sky130_fd_sc_hd__fill_1
XFILLER_44_462 VPWR VGND VPWR VGND sky130_ef_sc_hd__decap_12
XFILLER_71_281 VGND VGND VPWR VPWR sky130_fd_sc_hd__fill_1
XFILLER_16_197 VPWR VGND VPWR VGND sky130_ef_sc_hd__decap_12
XTAP_TAPCELL_ROW_14_332 VGND VPWR sky130_fd_sc_hd__tapvpwrvgnd_1
XFILLER_31_167 VGND VGND VPWR VPWR sky130_fd_sc_hd__fill_1
X_2740_ _0680_ _0692_ _0666_ VGND VGND VPWR VPWR _0693_ sky130_fd_sc_hd__a21o_1
X_2671_ _0621_ _0623_ _0620_ VGND VGND VPWR VPWR _0624_ sky130_fd_sc_hd__o21ai_2
X_4410_ clknet_leaf_0_clk _0375_ _0134_ VGND VGND VPWR VPWR systolic_unit_0.U_00.acc_0\[6\]
+ sky130_fd_sc_hd__dfrtp_1
X_4341_ clknet_leaf_26_clk net114 _0065_ VGND VGND VPWR VPWR systolic_unit_0.U_10.out_a\[1\]
+ sky130_fd_sc_hd__dfrtp_1
X_4272_ clknet_leaf_21_clk _0253_ _0008_ VGND VGND VPWR VPWR systolic_unit_0.U_11.acc_1\[8\]
+ sky130_fd_sc_hd__dfrtp_1
XFILLER_86_307 VGND VGND VPWR VPWR sky130_fd_sc_hd__fill_1
X_3223_ _1141_ _1142_ _1143_ VGND VGND VPWR VPWR _1144_ sky130_fd_sc_hd__and3_1
X_3154_ net160 net101 VGND VGND VPWR VPWR _1075_ sky130_fd_sc_hd__nand2_1
XFILLER_39_267 VGND VGND VPWR VPWR sky130_fd_sc_hd__decap_6
XFILLER_82_513 VPWR VGND VPWR VGND sky130_ef_sc_hd__decap_12
XFILLER_27_429 VGND VGND VPWR VPWR sky130_fd_sc_hd__decap_4
X_3085_ _1001_ _1005_ _0993_ VGND VGND VPWR VPWR _1006_ sky130_fd_sc_hd__a21oi_1
XFILLER_39_289 VPWR VGND VPWR VGND sky130_ef_sc_hd__decap_12
XFILLER_54_204 VPWR VGND VPWR VGND sky130_ef_sc_hd__decap_12
XFILLER_35_473 VGND VGND VPWR VPWR sky130_fd_sc_hd__fill_1
XFILLER_50_421 VPWR VGND VPWR VGND sky130_ef_sc_hd__decap_12
XFILLER_62_281 VGND VGND VPWR VPWR sky130_fd_sc_hd__fill_1
XFILLER_10_307 VGND VGND VPWR VPWR sky130_fd_sc_hd__fill_1
X_3987_ net97 _1748_ _1823_ _1845_ VGND VGND VPWR VPWR _0246_ sky130_fd_sc_hd__a31o_1
X_2938_ _0870_ _0890_ VGND VGND VPWR VPWR _0891_ sky130_fd_sc_hd__nor2_1
X_2869_ _0804_ _0805_ VGND VGND VPWR VPWR _0822_ sky130_fd_sc_hd__xor2_1
XFILLER_77_27 VPWR VGND VPWR VGND sky130_ef_sc_hd__decap_12
XFILLER_77_16 VGND VGND VPWR VPWR sky130_fd_sc_hd__fill_1
XFILLER_89_167 VGND VGND VPWR VPWR sky130_fd_sc_hd__fill_1
XFILLER_77_307 VPWR VGND VPWR VGND sky130_ef_sc_hd__decap_12
XFILLER_93_15 VPWR VGND VPWR VGND sky130_ef_sc_hd__decap_12
XFILLER_85_373 VPWR VGND VPWR VGND sky130_ef_sc_hd__decap_12
XTAP_TAPCELL_ROW_56_733 VGND VPWR sky130_fd_sc_hd__tapvpwrvgnd_1
XTAP_TAPCELL_ROW_28_468 VGND VPWR sky130_fd_sc_hd__tapvpwrvgnd_1
XFILLER_60_229 VPWR VGND VPWR VGND sky130_ef_sc_hd__decap_12
XFILLER_13_101 VGND VGND VPWR VPWR sky130_fd_sc_hd__fill_2
XFILLER_53_281 VGND VGND VPWR VPWR sky130_fd_sc_hd__decap_4
XFILLER_41_476 VPWR VGND VPWR VGND sky130_ef_sc_hd__decap_12
XTAP_TAPCELL_ROW_11_302 VGND VPWR sky130_fd_sc_hd__tapvpwrvgnd_1
XFILLER_9_127 VPWR VGND VPWR VGND sky130_ef_sc_hd__decap_12
XFILLER_42_85 VPWR VGND VPWR VGND sky130_ef_sc_hd__decap_12
XPHY_EDGE_ROW_39_Left_133 VGND VGND VPWR VPWR sky130_fd_sc_hd__decap_3
XFILLER_68_307 VGND VGND VPWR VPWR sky130_fd_sc_hd__fill_1
XFILLER_3_57 VPWR VGND VPWR VGND sky130_ef_sc_hd__decap_12
XFILLER_76_362 VGND VGND VPWR VPWR sky130_fd_sc_hd__fill_2
XPHY_EDGE_ROW_48_Left_142 VGND VGND VPWR VPWR sky130_fd_sc_hd__decap_3
XFILLER_64_524 VGND VGND VPWR VPWR sky130_fd_sc_hd__decap_8
XFILLER_83_81 VPWR VGND VPWR VGND sky130_ef_sc_hd__decap_12
X_3910_ systolic_unit_0.U_01.acc_0\[12\] net75 net82 systolic_unit_0.U_11.acc_0\[12\]
+ VGND VGND VPWR VPWR _1796_ sky130_fd_sc_hd__a22o_1
X_3841_ _1722_ _1728_ VGND VGND VPWR VPWR _1730_ sky130_fd_sc_hd__xor2_1
XFILLER_80_3 VPWR VGND VPWR VGND sky130_ef_sc_hd__decap_12
X_3772_ net187 net198 VGND VGND VPWR VPWR _1661_ sky130_fd_sc_hd__nand2_1
X_2723_ _0674_ _0675_ VGND VGND VPWR VPWR _0676_ sky130_fd_sc_hd__nor2_1
XPHY_EDGE_ROW_57_Left_151 VGND VGND VPWR VPWR sky130_fd_sc_hd__decap_3
X_2654_ systolic_unit_0.U_01.acc_1\[13\] systolic_unit_0.U_01.acc_0\[13\] net139 VGND
+ VGND VPWR VPWR _0607_ sky130_fd_sc_hd__mux2_1
X_2585_ _0538_ _0552_ VGND VGND VPWR VPWR _0567_ sky130_fd_sc_hd__xor2_1
X_4324_ clknet_leaf_28_clk _0305_ _0048_ VGND VGND VPWR VPWR systolic_unit_0.U_10.acc_0\[0\]
+ sky130_fd_sc_hd__dfrtp_1
Xfanout117 systolic_unit_0.U_01.in_b\[7\] VGND VGND VPWR VPWR net117 sky130_fd_sc_hd__buf_2
Xfanout128 net129 VGND VGND VPWR VPWR net128 sky130_fd_sc_hd__buf_2
Xfanout106 systolic_unit_0.U_10.in_a\[5\] VGND VGND VPWR VPWR net106 sky130_fd_sc_hd__dlymetal6s2s_1
X_4255_ net247 VGND VGND VPWR VPWR _0236_ sky130_fd_sc_hd__inv_2
Xfanout139 net140 VGND VGND VPWR VPWR net139 sky130_fd_sc_hd__buf_2
X_3206_ _1110_ _1112_ _1111_ VGND VGND VPWR VPWR _1127_ sky130_fd_sc_hd__a21o_1
X_4186_ net251 VGND VGND VPWR VPWR _0167_ sky130_fd_sc_hd__inv_2
XPHY_EDGE_ROW_66_Left_160 VGND VGND VPWR VPWR sky130_fd_sc_hd__decap_3
X_3137_ _1031_ _1055_ _1057_ VGND VGND VPWR VPWR _1058_ sky130_fd_sc_hd__nand3_1
XFILLER_55_502 VGND VGND VPWR VPWR sky130_fd_sc_hd__fill_2
XFILLER_55_513 VGND VGND VPWR VPWR sky130_fd_sc_hd__fill_2
XFILLER_27_248 VPWR VGND VPWR VGND sky130_ef_sc_hd__decap_12
XFILLER_82_365 VPWR VGND VPWR VGND sky130_ef_sc_hd__decap_12
X_3068_ _0978_ _0979_ _0988_ VGND VGND VPWR VPWR _0989_ sky130_fd_sc_hd__nor3_1
XTAP_TAPCELL_ROW_53_703 VGND VPWR sky130_fd_sc_hd__tapvpwrvgnd_1
XFILLER_23_421 VPWR VGND VPWR VGND sky130_ef_sc_hd__decap_12
XTAP_TAPCELL_ROW_25_438 VGND VPWR sky130_fd_sc_hd__tapvpwrvgnd_1
XFILLER_23_443 VGND VGND VPWR VPWR sky130_fd_sc_hd__decap_4
XFILLER_50_251 VGND VGND VPWR VPWR sky130_fd_sc_hd__fill_1
XTAP_TAPCELL_ROW_61_780 VGND VPWR sky130_fd_sc_hd__tapvpwrvgnd_1
XFILLER_10_137 VGND VGND VPWR VPWR sky130_fd_sc_hd__decap_3
XFILLER_88_15 VPWR VGND VPWR VGND sky130_ef_sc_hd__decap_12
XFILLER_77_137 VGND VGND VPWR VPWR sky130_fd_sc_hd__decap_6
XFILLER_77_148 VGND VGND VPWR VPWR sky130_fd_sc_hd__decap_4
XFILLER_18_215 VPWR VGND VPWR VGND sky130_ef_sc_hd__decap_12
XFILLER_46_513 VGND VGND VPWR VPWR sky130_fd_sc_hd__decap_8
XFILLER_58_362 VGND VGND VPWR VPWR sky130_fd_sc_hd__fill_2
XFILLER_85_181 VPWR VGND VPWR VGND sky130_ef_sc_hd__decap_12
XFILLER_73_332 VGND VGND VPWR VPWR sky130_fd_sc_hd__decap_4
XFILLER_37_52 VGND VGND VPWR VPWR sky130_fd_sc_hd__decap_4
XFILLER_73_387 VGND VGND VPWR VPWR sky130_fd_sc_hd__decap_4
XFILLER_61_505 VPWR VGND VPWR VGND sky130_ef_sc_hd__decap_12
XFILLER_14_421 VPWR VGND VPWR VGND sky130_ef_sc_hd__decap_12
XFILLER_5_141 VPWR VGND VPWR VGND sky130_ef_sc_hd__decap_12
X_2370_ _2053_ _2067_ _2027_ _2036_ VGND VGND VPWR VPWR _2069_ sky130_fd_sc_hd__o211a_1
XFILLER_68_126 VPWR VGND VPWR VGND sky130_ef_sc_hd__decap_12
X_4040_ net243 VGND VGND VPWR VPWR _0021_ sky130_fd_sc_hd__inv_2
XTAP_TAPCELL_ROW_67_839 VGND VPWR sky130_fd_sc_hd__tapvpwrvgnd_1
XFILLER_37_546 VGND VGND VPWR VPWR sky130_fd_sc_hd__decap_4
XFILLER_64_343 VGND VGND VPWR VPWR sky130_fd_sc_hd__fill_1
XFILLER_64_365 VPWR VGND VPWR VGND sky130_ef_sc_hd__decap_12
XFILLER_17_281 VPWR VGND VPWR VGND sky130_ef_sc_hd__decap_12
XFILLER_20_402 VGND VGND VPWR VPWR sky130_fd_sc_hd__fill_1
XTAP_TAPCELL_ROW_22_408 VGND VPWR sky130_fd_sc_hd__tapvpwrvgnd_1
X_3824_ _1703_ _1712_ VGND VGND VPWR VPWR _1713_ sky130_fd_sc_hd__nor2_1
X_3755_ _1607_ _1608_ VGND VGND VPWR VPWR _1644_ sky130_fd_sc_hd__xnor2_2
X_2706_ _0635_ _0644_ _0657_ VGND VGND VPWR VPWR _0659_ sky130_fd_sc_hd__and3_1
X_3686_ _1566_ _1567_ VGND VGND VPWR VPWR _1575_ sky130_fd_sc_hd__xor2_1
XTAP_TAPCELL_ROW_30_485 VGND VPWR sky130_fd_sc_hd__tapvpwrvgnd_1
XPHY_EDGE_ROW_12_Right_12 VGND VGND VPWR VPWR sky130_fd_sc_hd__decap_3
X_2637_ net100 _0512_ _0589_ net80 net359 VGND VGND VPWR VPWR _0353_ sky130_fd_sc_hd__a32o_1
X_2568_ _0546_ _0547_ _0552_ VGND VGND VPWR VPWR _0553_ sky130_fd_sc_hd__or3_1
XFILLER_58_29 VPWR VGND VPWR VGND sky130_ef_sc_hd__decap_12
XFILLER_87_424 VPWR VGND VPWR VGND sky130_ef_sc_hd__decap_12
X_4307_ clknet_leaf_17_clk _0288_ _0031_ VGND VGND VPWR VPWR systolic_unit_0.U_11.acc_0\[15\]
+ sky130_fd_sc_hd__dfrtp_1
X_2499_ _0461_ _0470_ _0482_ VGND VGND VPWR VPWR _0484_ sky130_fd_sc_hd__a21oi_1
X_4238_ net225 VGND VGND VPWR VPWR _0219_ sky130_fd_sc_hd__inv_2
XFILLER_59_148 VPWR VGND VPWR VGND sky130_ef_sc_hd__decap_12
X_4169_ net235 VGND VGND VPWR VPWR _0150_ sky130_fd_sc_hd__inv_2
XFILLER_67_181 VPWR VGND VPWR VGND sky130_ef_sc_hd__decap_12
XPHY_EDGE_ROW_21_Right_21 VGND VGND VPWR VPWR sky130_fd_sc_hd__decap_3
XTAP_TAPCELL_ROW_38_563 VGND VPWR sky130_fd_sc_hd__tapvpwrvgnd_1
XFILLER_82_195 VGND VGND VPWR VPWR sky130_fd_sc_hd__fill_1
XFILLER_90_27 VGND VGND VPWR VPWR sky130_fd_sc_hd__fill_1
XFILLER_7_417 VPWR VGND VPWR VGND sky130_ef_sc_hd__decap_12
XPHY_EDGE_ROW_30_Right_30 VGND VGND VPWR VPWR sky130_fd_sc_hd__decap_3
XFILLER_93_405 VPWR VGND VPWR VGND sky130_ef_sc_hd__decap_12
XFILLER_93_449 VPWR VGND VPWR VGND sky130_ef_sc_hd__decap_12
XFILLER_46_321 VPWR VGND VPWR VGND sky130_ef_sc_hd__decap_12
XFILLER_73_151 VGND VGND VPWR VPWR sky130_fd_sc_hd__decap_6
XFILLER_0_69 VPWR VGND VPWR VGND sky130_ef_sc_hd__decap_12
XTAP_TAPCELL_ROW_64_809 VGND VPWR sky130_fd_sc_hd__tapvpwrvgnd_1
XFILLER_61_324 VPWR VGND VPWR VGND sky130_ef_sc_hd__decap_12
XFILLER_64_83 VGND VGND VPWR VPWR sky130_fd_sc_hd__fill_1
XTAP_TAPCELL_ROW_72_886 VGND VPWR sky130_fd_sc_hd__tapvpwrvgnd_1
X_3540_ _1422_ _1427_ VGND VGND VPWR VPWR _1429_ sky130_fd_sc_hd__xnor2_1
X_3471_ net317 _1356_ _1381_ _1382_ VGND VGND VPWR VPWR _0311_ sky130_fd_sc_hd__a22o_1
XFILLER_43_3 VGND VGND VPWR VPWR sky130_fd_sc_hd__decap_8
X_2422_ _2118_ _2119_ _2120_ VGND VGND VPWR VPWR _2121_ sky130_fd_sc_hd__nand3_1
X_2353_ _2049_ _2050_ _2044_ VGND VGND VPWR VPWR _2052_ sky130_fd_sc_hd__a21bo_1
X_2284_ net268 net214 VGND VGND VPWR VPWR _1983_ sky130_fd_sc_hd__nand2_1
X_4023_ net240 VGND VGND VPWR VPWR _0004_ sky130_fd_sc_hd__inv_2
XTAP_TAPCELL_ROW_35_533 VGND VPWR sky130_fd_sc_hd__tapvpwrvgnd_1
X_3807_ _1637_ _1638_ VGND VGND VPWR VPWR _1696_ sky130_fd_sc_hd__xor2_1
X_3738_ _1614_ _1620_ VGND VGND VPWR VPWR _1627_ sky130_fd_sc_hd__xor2_2
X_3669_ _1556_ _1557_ VGND VGND VPWR VPWR _1558_ sky130_fd_sc_hd__nor2_1
XTAP_TAPCELL_ROW_7_269 VGND VPWR sky130_fd_sc_hd__tapvpwrvgnd_1
XFILLER_87_265 VGND VGND VPWR VPWR sky130_fd_sc_hd__decap_8
XFILLER_85_27 VPWR VGND VPWR VGND sky130_ef_sc_hd__decap_12
XFILLER_75_416 VGND VGND VPWR VPWR sky130_fd_sc_hd__fill_1
XFILLER_75_405 VGND VGND VPWR VPWR sky130_fd_sc_hd__decap_3
XFILLER_75_449 VPWR VGND VPWR VGND sky130_ef_sc_hd__decap_12
XTAP_TAPCELL_ROW_87_1030 VGND VPWR sky130_fd_sc_hd__tapvpwrvgnd_1
XFILLER_28_365 VGND VGND VPWR VPWR sky130_fd_sc_hd__decap_8
XFILLER_70_110 VPWR VGND VPWR VGND sky130_ef_sc_hd__decap_12
XFILLER_28_398 VGND VGND VPWR VPWR sky130_fd_sc_hd__decap_4
XFILLER_43_368 VPWR VGND VPWR VGND sky130_ef_sc_hd__decap_12
XFILLER_11_276 VGND VGND VPWR VPWR sky130_fd_sc_hd__decap_4
XFILLER_3_497 VGND VGND VPWR VPWR sky130_fd_sc_hd__decap_6
XFILLER_78_265 VPWR VGND VPWR VGND sky130_ef_sc_hd__decap_12
XTAP_TAPCELL_ROW_77_934 VGND VPWR sky130_fd_sc_hd__tapvpwrvgnd_1
XTAP_TAPCELL_ROW_49_669 VGND VPWR sky130_fd_sc_hd__tapvpwrvgnd_1
XFILLER_34_368 VGND VGND VPWR VPWR sky130_fd_sc_hd__fill_1
X_2971_ _0842_ _0866_ _0868_ VGND VGND VPWR VPWR _0924_ sky130_fd_sc_hd__nand3_1
XTAP_TAPCELL_ROW_32_503 VGND VPWR sky130_fd_sc_hd__tapvpwrvgnd_1
XFILLER_61_154 VGND VGND VPWR VPWR sky130_fd_sc_hd__decap_6
XFILLER_61_165 VGND VGND VPWR VPWR sky130_fd_sc_hd__decap_3
XFILLER_91_81 VPWR VGND VPWR VGND sky130_ef_sc_hd__decap_12
XFILLER_61_198 VGND VGND VPWR VPWR sky130_fd_sc_hd__decap_8
XTAP_TAPCELL_ROW_40_580 VGND VPWR sky130_fd_sc_hd__tapvpwrvgnd_1
X_3523_ net134 _1386_ VGND VGND VPWR VPWR _1417_ sky130_fd_sc_hd__nor2_1
X_3454_ systolic_unit_0.U_00.acc_0\[10\] net206 net136 VGND VGND VPWR VPWR _1370_
+ sky130_fd_sc_hd__a21o_1
XFILLER_69_210 VGND VGND VPWR VPWR sky130_fd_sc_hd__decap_8
X_2405_ _2068_ _2075_ _2092_ _2101_ VGND VGND VPWR VPWR _2104_ sky130_fd_sc_hd__a211o_1
X_3385_ net116 net161 net114 net164 VGND VGND VPWR VPWR _1306_ sky130_fd_sc_hd__a22o_1
X_2336_ _2029_ _2031_ VGND VGND VPWR VPWR _2035_ sky130_fd_sc_hd__xnor2_1
XFILLER_69_254 VGND VGND VPWR VPWR sky130_fd_sc_hd__fill_2
XTAP_TAPCELL_ROW_4_239 VGND VPWR sky130_fd_sc_hd__tapvpwrvgnd_1
XFILLER_84_235 VPWR VGND VPWR VGND sky130_ef_sc_hd__decap_12
X_2267_ net264 net263 net216 net214 VGND VGND VPWR VPWR _1966_ sky130_fd_sc_hd__nand4_1
XFILLER_57_449 VPWR VGND VPWR VGND sky130_ef_sc_hd__decap_12
XFILLER_72_419 VGND VGND VPWR VPWR sky130_fd_sc_hd__fill_1
X_4006_ matrix_count\[2\] net37 VGND VGND VPWR VPWR _1855_ sky130_fd_sc_hd__or2_1
X_2198_ systolic_unit_0.U_11.acc_0\[1\] systolic_unit_0.U_11.acc_1\[1\] net145 VGND
+ VGND VPWR VPWR _1899_ sky130_fd_sc_hd__mux2_1
XFILLER_21_541 VPWR VGND VPWR VGND sky130_ef_sc_hd__decap_12
XFILLER_20_77 VGND VGND VPWR VPWR sky130_fd_sc_hd__fill_1
XFILLER_0_445 VGND VGND VPWR VPWR sky130_fd_sc_hd__decap_3
XFILLER_0_489 VPWR VGND VPWR VGND sky130_ef_sc_hd__decap_12
Xhold31 systolic_unit_0.U_10.acc_1\[5\] VGND VGND VPWR VPWR net306 sky130_fd_sc_hd__dlygate4sd3_1
Xhold20 systolic_unit_0.U_10.acc_1\[10\] VGND VGND VPWR VPWR net295 sky130_fd_sc_hd__dlygate4sd3_1
XFILLER_48_427 VGND VGND VPWR VPWR sky130_fd_sc_hd__decap_6
Xhold53 systolic_unit_0.U_10.in_a\[5\] VGND VGND VPWR VPWR net328 sky130_fd_sc_hd__dlygate4sd3_1
Xhold42 systolic_unit_0.U_10.acc_0\[6\] VGND VGND VPWR VPWR net317 sky130_fd_sc_hd__dlygate4sd3_1
Xhold64 net54 VGND VGND VPWR VPWR net339 sky130_fd_sc_hd__dlygate4sd3_1
XTAP_TAPCELL_ROW_74_904 VGND VPWR sky130_fd_sc_hd__tapvpwrvgnd_1
XPHY_EDGE_ROW_11_Left_105 VGND VGND VPWR VPWR sky130_fd_sc_hd__decap_3
Xhold86 _0271_ VGND VGND VPWR VPWR net361 sky130_fd_sc_hd__dlygate4sd3_1
Xhold75 net58 VGND VGND VPWR VPWR net350 sky130_fd_sc_hd__dlygate4sd3_1
Xhold97 systolic_unit_0.U_01.acc_1\[9\] VGND VGND VPWR VPWR net372 sky130_fd_sc_hd__dlygate4sd3_1
XFILLER_28_151 VGND VGND VPWR VPWR sky130_fd_sc_hd__decap_3
XFILLER_28_184 VPWR VGND VPWR VGND sky130_ef_sc_hd__decap_12
XTAP_TAPCELL_ROW_46_639 VGND VPWR sky130_fd_sc_hd__tapvpwrvgnd_1
XTAP_TAPCELL_ROW_82_981 VGND VPWR sky130_fd_sc_hd__tapvpwrvgnd_1
XFILLER_43_165 VGND VGND VPWR VPWR sky130_fd_sc_hd__decap_3
XFILLER_31_327 VGND VGND VPWR VPWR sky130_fd_sc_hd__fill_2
XFILLER_8_501 VPWR VGND VPWR VGND sky130_ef_sc_hd__decap_12
XFILLER_8_545 VGND VGND VPWR VPWR sky130_fd_sc_hd__decap_8
XPHY_EDGE_ROW_20_Left_114 VGND VGND VPWR VPWR sky130_fd_sc_hd__decap_3
XFILLER_79_541 VPWR VGND VPWR VGND sky130_ef_sc_hd__decap_12
X_3170_ net158 net156 net107 net105 VGND VGND VPWR VPWR _1091_ sky130_fd_sc_hd__and4_1
XFILLER_39_449 VGND VGND VPWR VPWR sky130_fd_sc_hd__decap_3
XTAP_TAPCELL_ROW_1_209 VGND VPWR sky130_fd_sc_hd__tapvpwrvgnd_1
XFILLER_54_419 VGND VGND VPWR VPWR sky130_fd_sc_hd__fill_1
XFILLER_19_184 VGND VGND VPWR VPWR sky130_fd_sc_hd__decap_3
XTAP_TAPCELL_ROW_17_363 VGND VPWR sky130_fd_sc_hd__tapvpwrvgnd_1
XFILLER_34_154 VGND VGND VPWR VPWR sky130_fd_sc_hd__decap_6
XFILLER_34_187 VGND VGND VPWR VPWR sky130_fd_sc_hd__decap_8
X_2954_ _0905_ _0906_ VGND VGND VPWR VPWR _0907_ sky130_fd_sc_hd__nand2_1
X_2885_ _0823_ _0834_ VGND VGND VPWR VPWR _0838_ sky130_fd_sc_hd__xnor2_1
XPHY_EDGE_ROW_6_Right_6 VGND VGND VPWR VPWR sky130_fd_sc_hd__decap_3
X_3506_ net96 _1359_ _1408_ VGND VGND VPWR VPWR _0302_ sky130_fd_sc_hd__a21o_1
X_4486_ clknet_leaf_27_clk net294 _0210_ VGND VGND VPWR VPWR systolic_unit_0.out_acc_0_r1\[1\]
+ sky130_fd_sc_hd__dfrtp_1
X_3437_ _1354_ _1355_ _1356_ net293 VGND VGND VPWR VPWR _0319_ sky130_fd_sc_hd__a22o_1
X_3368_ systolic_unit_0.U_10.acc_1\[2\] systolic_unit_0.U_10.acc_0\[2\] net137 VGND
+ VGND VPWR VPWR _1289_ sky130_fd_sc_hd__mux2_1
X_2319_ net220 net260 net256 net267 VGND VGND VPWR VPWR _2018_ sky130_fd_sc_hd__a22o_1
X_3299_ _1208_ _1210_ _1209_ VGND VGND VPWR VPWR _1220_ sky130_fd_sc_hd__a21oi_1
XTAP_TAPCELL_ROW_84_1000 VGND VPWR sky130_fd_sc_hd__tapvpwrvgnd_1
XFILLER_38_482 VGND VGND VPWR VPWR sky130_fd_sc_hd__decap_3
XFILLER_25_110 VGND VGND VPWR VPWR sky130_fd_sc_hd__fill_2
XTAP_TAPCELL_ROW_43_609 VGND VPWR sky130_fd_sc_hd__tapvpwrvgnd_1
XFILLER_13_349 VPWR VGND VPWR VGND sky130_ef_sc_hd__decap_12
XFILLER_40_135 VGND VGND VPWR VPWR sky130_fd_sc_hd__decap_4
XFILLER_15_88 VGND VGND VPWR VPWR sky130_fd_sc_hd__fill_1
XTAP_TAPCELL_ROW_51_686 VGND VPWR sky130_fd_sc_hd__tapvpwrvgnd_1
XFILLER_21_393 VGND VGND VPWR VPWR sky130_fd_sc_hd__decap_3
Xoutput43 net43 VGND VGND VPWR VPWR D_c_flat[13] sky130_fd_sc_hd__buf_2
Xoutput65 net65 VGND VGND VPWR VPWR D_c_flat[4] sky130_fd_sc_hd__buf_2
Xoutput54 net54 VGND VGND VPWR VPWR D_c_flat[23] sky130_fd_sc_hd__buf_2
XFILLER_0_253 VGND VGND VPWR VPWR sky130_fd_sc_hd__fill_2
XFILLER_76_533 VPWR VGND VPWR VGND sky130_ef_sc_hd__decap_12
XFILLER_0_286 VGND VGND VPWR VPWR sky130_fd_sc_hd__decap_4
XFILLER_91_503 VGND VGND VPWR VPWR sky130_fd_sc_hd__fill_1
XTAP_TAPCELL_ROW_59_764 VGND VPWR sky130_fd_sc_hd__tapvpwrvgnd_1
XFILLER_44_441 VGND VGND VPWR VPWR sky130_fd_sc_hd__fill_1
XFILLER_56_290 VGND VGND VPWR VPWR sky130_fd_sc_hd__decap_8
XFILLER_63_238 VGND VGND VPWR VPWR sky130_fd_sc_hd__decap_6
XFILLER_44_474 VGND VGND VPWR VPWR sky130_fd_sc_hd__fill_2
XFILLER_31_113 VGND VGND VPWR VPWR sky130_fd_sc_hd__decap_3
XFILLER_72_83 VGND VGND VPWR VPWR sky130_fd_sc_hd__fill_1
XTAP_TAPCELL_ROW_14_333 VGND VPWR sky130_fd_sc_hd__tapvpwrvgnd_1
XPHY_EDGE_ROW_59_Right_59 VGND VGND VPWR VPWR sky130_fd_sc_hd__decap_3
X_2670_ _0621_ _0622_ net170 net117 VGND VGND VPWR VPWR _0623_ sky130_fd_sc_hd__and4bb_1
X_4340_ clknet_leaf_26_clk net115 _0064_ VGND VGND VPWR VPWR systolic_unit_0.U_10.out_a\[0\]
+ sky130_fd_sc_hd__dfrtp_1
X_4271_ clknet_leaf_18_clk _0252_ _0007_ VGND VGND VPWR VPWR systolic_unit_0.U_11.acc_1\[7\]
+ sky130_fd_sc_hd__dfrtp_1
X_3222_ systolic_unit_0.U_10.acc_1\[7\] systolic_unit_0.U_10.acc_0\[7\] net133 VGND
+ VGND VPWR VPWR _1143_ sky130_fd_sc_hd__mux2_1
XFILLER_79_393 VPWR VGND VPWR VGND sky130_ef_sc_hd__decap_12
XFILLER_79_371 VGND VGND VPWR VPWR sky130_fd_sc_hd__fill_2
XPHY_EDGE_ROW_68_Right_68 VGND VGND VPWR VPWR sky130_fd_sc_hd__decap_3
X_3153_ _1072_ _1073_ VGND VGND VPWR VPWR _1074_ sky130_fd_sc_hd__and2b_1
XFILLER_82_525 VGND VGND VPWR VPWR sky130_fd_sc_hd__decap_6
X_3084_ _1003_ _1004_ VGND VGND VPWR VPWR _1005_ sky130_fd_sc_hd__nand2_1
XFILLER_39_279 VGND VGND VPWR VPWR sky130_fd_sc_hd__fill_1
XFILLER_54_216 VGND VGND VPWR VPWR sky130_fd_sc_hd__decap_8
XFILLER_50_433 VPWR VGND VPWR VGND sky130_ef_sc_hd__decap_12
XPHY_EDGE_ROW_77_Right_77 VGND VGND VPWR VPWR sky130_fd_sc_hd__decap_3
XFILLER_22_157 VGND VGND VPWR VPWR sky130_fd_sc_hd__fill_1
X_3986_ systolic_unit_0.U_11.acc_1\[1\] net74 net81 systolic_unit_0.U_01.acc_1\[1\]
+ VGND VGND VPWR VPWR _1845_ sky130_fd_sc_hd__a22o_1
X_2937_ _0871_ _0889_ VGND VGND VPWR VPWR _0890_ sky130_fd_sc_hd__nand2_1
XFILLER_50_477 VPWR VGND VPWR VGND sky130_ef_sc_hd__decap_12
X_2868_ _0820_ _0818_ VGND VGND VPWR VPWR _0821_ sky130_fd_sc_hd__and2b_1
X_2799_ net124 net169 net168 net126 VGND VGND VPWR VPWR _0752_ sky130_fd_sc_hd__a22oi_1
XFILLER_89_113 VPWR VGND VPWR VGND sky130_ef_sc_hd__decap_12
X_4469_ clknet_leaf_28_clk net308 _0193_ VGND VGND VPWR VPWR systolic_unit_0.out_acc_1_r1\[0\]
+ sky130_fd_sc_hd__dfrtp_1
XPHY_EDGE_ROW_86_Right_86 VGND VGND VPWR VPWR sky130_fd_sc_hd__decap_3
XFILLER_77_319 VPWR VGND VPWR VGND sky130_ef_sc_hd__decap_12
XFILLER_77_39 VPWR VGND VPWR VGND sky130_ef_sc_hd__decap_12
XFILLER_85_330 VGND VGND VPWR VPWR sky130_fd_sc_hd__decap_6
XFILLER_18_408 VPWR VGND VPWR VGND sky130_ef_sc_hd__decap_12
XFILLER_93_27 VGND VGND VPWR VPWR sky130_fd_sc_hd__fill_1
XFILLER_85_385 VGND VGND VPWR VPWR sky130_fd_sc_hd__decap_6
XTAP_TAPCELL_ROW_56_734 VGND VPWR sky130_fd_sc_hd__tapvpwrvgnd_1
XTAP_TAPCELL_ROW_28_469 VGND VPWR sky130_fd_sc_hd__tapvpwrvgnd_1
XFILLER_13_113 VGND VGND VPWR VPWR sky130_fd_sc_hd__fill_2
XTAP_TAPCELL_ROW_11_303 VGND VPWR sky130_fd_sc_hd__tapvpwrvgnd_1
XFILLER_9_139 VPWR VGND VPWR VGND sky130_ef_sc_hd__decap_12
XFILLER_41_488 VGND VGND VPWR VPWR sky130_fd_sc_hd__decap_8
XFILLER_5_389 VGND VGND VPWR VPWR sky130_fd_sc_hd__decap_3
XFILLER_3_69 VPWR VGND VPWR VGND sky130_ef_sc_hd__decap_12
XFILLER_49_533 VGND VGND VPWR VPWR sky130_fd_sc_hd__fill_1
XFILLER_36_249 VGND VGND VPWR VPWR sky130_fd_sc_hd__decap_3
XFILLER_83_93 VPWR VGND VPWR VGND sky130_ef_sc_hd__decap_12
XFILLER_32_400 VGND VGND VPWR VPWR sky130_fd_sc_hd__decap_6
X_3840_ _1722_ _1728_ VGND VGND VPWR VPWR _1729_ sky130_fd_sc_hd__and2_1
X_3771_ net189 net196 _1658_ VGND VGND VPWR VPWR _1660_ sky130_fd_sc_hd__and3_1
XFILLER_32_477 VPWR VGND VPWR VGND sky130_ef_sc_hd__decap_12
X_2722_ net122 net167 _0672_ _0673_ VGND VGND VPWR VPWR _0675_ sky130_fd_sc_hd__o2bb2a_1
X_2653_ _0596_ _0600_ VGND VGND VPWR VPWR _0606_ sky130_fd_sc_hd__xnor2_1
X_2584_ net384 net88 _0566_ net209 VGND VGND VPWR VPWR _0382_ sky130_fd_sc_hd__a22o_1
X_4323_ clknet_leaf_3_clk _0304_ _0047_ VGND VGND VPWR VPWR systolic_unit_0.U_10.acc_1\[15\]
+ sky130_fd_sc_hd__dfrtp_1
Xfanout118 systolic_unit_0.U_01.in_b\[7\] VGND VGND VPWR VPWR net118 sky130_fd_sc_hd__dlymetal6s2s_1
Xfanout129 systolic_unit_0.U_01.in_b\[1\] VGND VGND VPWR VPWR net129 sky130_fd_sc_hd__buf_2
Xfanout107 net108 VGND VGND VPWR VPWR net107 sky130_fd_sc_hd__buf_2
X_4254_ net247 VGND VGND VPWR VPWR _0235_ sky130_fd_sc_hd__inv_2
X_3205_ _1115_ _1119_ _1118_ VGND VGND VPWR VPWR _1126_ sky130_fd_sc_hd__a21oi_1
X_4185_ net252 VGND VGND VPWR VPWR _0166_ sky130_fd_sc_hd__inv_2
X_3136_ _1051_ _1056_ VGND VGND VPWR VPWR _1057_ sky130_fd_sc_hd__nand2b_1
X_3067_ _0982_ _0987_ VGND VGND VPWR VPWR _0988_ sky130_fd_sc_hd__nand2b_1
XFILLER_82_377 VPWR VGND VPWR VGND sky130_ef_sc_hd__decap_12
XFILLER_42_208 VGND VGND VPWR VPWR sky130_fd_sc_hd__fill_1
XTAP_TAPCELL_ROW_53_704 VGND VPWR sky130_fd_sc_hd__tapvpwrvgnd_1
XTAP_TAPCELL_ROW_25_439 VGND VPWR sky130_fd_sc_hd__tapvpwrvgnd_1
XFILLER_23_433 VGND VGND VPWR VPWR sky130_fd_sc_hd__decap_6
XFILLER_50_230 VGND VGND VPWR VPWR sky130_fd_sc_hd__fill_1
XTAP_TAPCELL_ROW_61_781 VGND VPWR sky130_fd_sc_hd__tapvpwrvgnd_1
X_3969_ _1867_ _1800_ _1836_ VGND VGND VPWR VPWR _0255_ sky130_fd_sc_hd__a21o_1
XFILLER_50_296 VGND VGND VPWR VPWR sky130_fd_sc_hd__fill_1
XFILLER_88_27 VGND VGND VPWR VPWR sky130_fd_sc_hd__fill_1
XFILLER_77_105 VGND VGND VPWR VPWR sky130_fd_sc_hd__decap_6
XFILLER_85_193 VPWR VGND VPWR VGND sky130_ef_sc_hd__decap_12
XFILLER_73_344 VPWR VGND VPWR VGND sky130_ef_sc_hd__decap_12
XFILLER_18_227 VGND VGND VPWR VPWR sky130_fd_sc_hd__decap_3
XFILLER_18_238 VGND VGND VPWR VPWR sky130_fd_sc_hd__fill_1
XFILLER_46_536 VGND VGND VPWR VPWR sky130_fd_sc_hd__fill_2
XFILLER_73_366 VGND VGND VPWR VPWR sky130_fd_sc_hd__decap_6
XFILLER_61_517 VPWR VGND VPWR VGND sky130_ef_sc_hd__decap_12
XFILLER_14_433 VPWR VGND VPWR VGND sky130_ef_sc_hd__decap_12
XFILLER_14_477 VGND VGND VPWR VPWR sky130_fd_sc_hd__decap_4
XFILLER_5_153 VPWR VGND VPWR VGND sky130_ef_sc_hd__decap_12
XFILLER_78_60 VGND VGND VPWR VPWR sky130_fd_sc_hd__decap_4
XFILLER_78_93 VGND VGND VPWR VPWR sky130_fd_sc_hd__decap_3
XFILLER_78_82 VGND VGND VPWR VPWR sky130_fd_sc_hd__fill_2
XFILLER_68_138 VGND VGND VPWR VPWR sky130_fd_sc_hd__fill_2
XFILLER_64_377 VGND VGND VPWR VPWR sky130_fd_sc_hd__fill_1
XFILLER_17_293 VPWR VGND VPWR VGND sky130_ef_sc_hd__decap_12
XFILLER_20_414 VGND VGND VPWR VPWR sky130_fd_sc_hd__decap_6
XTAP_TAPCELL_ROW_22_409 VGND VPWR sky130_fd_sc_hd__tapvpwrvgnd_1
X_3823_ net203 net186 net183 net204 VGND VGND VPWR VPWR _1712_ sky130_fd_sc_hd__a22oi_1
X_3754_ _1641_ _1642_ _1640_ VGND VGND VPWR VPWR _1643_ sky130_fd_sc_hd__a21boi_1
X_2705_ _0644_ _0657_ _0635_ VGND VGND VPWR VPWR _0658_ sky130_fd_sc_hd__a21oi_1
X_3685_ _1570_ _1571_ VGND VGND VPWR VPWR _1574_ sky130_fd_sc_hd__xnor2_1
XTAP_TAPCELL_ROW_30_486 VGND VPWR sky130_fd_sc_hd__tapvpwrvgnd_1
X_2636_ net100 _0588_ net80 net405 VGND VGND VPWR VPWR _0354_ sky130_fd_sc_hd__a22o_1
X_2567_ _0550_ _0551_ VGND VGND VPWR VPWR _0552_ sky130_fd_sc_hd__nand2_1
XFILLER_87_436 VPWR VGND VPWR VGND sky130_ef_sc_hd__decap_12
X_4306_ clknet_leaf_16_clk _0287_ _0030_ VGND VGND VPWR VPWR systolic_unit_0.U_11.acc_0\[14\]
+ sky130_fd_sc_hd__dfrtp_1
X_2498_ _0461_ _0470_ _0482_ VGND VGND VPWR VPWR _0483_ sky130_fd_sc_hd__and3_1
X_4237_ net222 VGND VGND VPWR VPWR _0218_ sky130_fd_sc_hd__inv_2
X_4168_ net235 VGND VGND VPWR VPWR _0149_ sky130_fd_sc_hd__inv_2
XFILLER_74_29 VPWR VGND VPWR VGND sky130_ef_sc_hd__decap_12
XFILLER_67_193 VPWR VGND VPWR VGND sky130_ef_sc_hd__decap_12
XFILLER_82_141 VPWR VGND VPWR VGND sky130_ef_sc_hd__decap_12
X_3119_ _1037_ _1038_ _1036_ VGND VGND VPWR VPWR _1040_ sky130_fd_sc_hd__a21boi_1
XTAP_TAPCELL_ROW_38_564 VGND VPWR sky130_fd_sc_hd__tapvpwrvgnd_1
XFILLER_55_377 VGND VGND VPWR VPWR sky130_fd_sc_hd__decap_8
X_4099_ net245 VGND VGND VPWR VPWR _0080_ sky130_fd_sc_hd__inv_2
XFILLER_23_230 VPWR VGND VPWR VGND sky130_ef_sc_hd__decap_12
XFILLER_11_447 VGND VGND VPWR VPWR sky130_fd_sc_hd__fill_1
XFILLER_7_429 VPWR VGND VPWR VGND sky130_ef_sc_hd__decap_12
XFILLER_23_66 VPWR VGND VPWR VGND sky130_ef_sc_hd__decap_12
XFILLER_3_3 VPWR VGND VPWR VGND sky130_ef_sc_hd__decap_12
XFILLER_78_425 VGND VGND VPWR VPWR sky130_fd_sc_hd__fill_1
XFILLER_93_417 VGND VGND VPWR VPWR sky130_fd_sc_hd__decap_3
XFILLER_19_503 VGND VGND VPWR VPWR sky130_fd_sc_hd__fill_1
XFILLER_48_85 VPWR VGND VPWR VGND sky130_ef_sc_hd__decap_12
XFILLER_0_15 VPWR VGND VPWR VGND sky130_ef_sc_hd__decap_12
XFILLER_46_333 VPWR VGND VPWR VGND sky130_ef_sc_hd__decap_12
XFILLER_58_193 VGND VGND VPWR VPWR sky130_fd_sc_hd__decap_3
XFILLER_73_163 VGND VGND VPWR VPWR sky130_fd_sc_hd__decap_4
XFILLER_61_303 VGND VGND VPWR VPWR sky130_fd_sc_hd__fill_1
XPHY_EDGE_ROW_85_Left_179 VGND VGND VPWR VPWR sky130_fd_sc_hd__decap_3
XFILLER_61_358 VGND VGND VPWR VPWR sky130_fd_sc_hd__decap_4
XTAP_TAPCELL_ROW_72_887 VGND VPWR sky130_fd_sc_hd__tapvpwrvgnd_1
XFILLER_9_57 VPWR VGND VPWR VGND sky130_ef_sc_hd__decap_12
X_3470_ systolic_unit_0.U_00.acc_0\[6\] net206 net276 VGND VGND VPWR VPWR _1382_ sky130_fd_sc_hd__a21o_1
XFILLER_89_81 VPWR VGND VPWR VGND sky130_ef_sc_hd__decap_12
X_2421_ net266 net265 net262 net274 VGND VGND VPWR VPWR _2120_ sky130_fd_sc_hd__a22o_1
XFILLER_36_3 VGND VGND VPWR VPWR sky130_fd_sc_hd__decap_6
X_2352_ _2044_ _2049_ _2050_ VGND VGND VPWR VPWR _2051_ sky130_fd_sc_hd__nand3_1
X_2283_ net264 net263 net218 net216 VGND VGND VPWR VPWR _1982_ sky130_fd_sc_hd__and4_1
X_4022_ net243 VGND VGND VPWR VPWR _0003_ sky130_fd_sc_hd__inv_2
XFILLER_64_141 VPWR VGND VPWR VGND sky130_ef_sc_hd__decap_12
XTAP_TAPCELL_ROW_35_534 VGND VPWR sky130_fd_sc_hd__tapvpwrvgnd_1
X_3806_ _1630_ _1688_ _1694_ _1693_ _1670_ VGND VGND VPWR VPWR _1695_ sky130_fd_sc_hd__a32oi_4
X_3737_ _1622_ _1625_ VGND VGND VPWR VPWR _1626_ sky130_fd_sc_hd__xnor2_2
XFILLER_69_18 VPWR VGND VPWR VGND sky130_ef_sc_hd__decap_12
X_3668_ net198 net181 net180 net200 VGND VGND VPWR VPWR _1557_ sky130_fd_sc_hd__a22oi_1
X_3599_ _1483_ _1487_ VGND VGND VPWR VPWR _1488_ sky130_fd_sc_hd__xnor2_1
X_2619_ net272 net274 _0511_ VGND VGND VPWR VPWR _0589_ sky130_fd_sc_hd__a21o_1
XFILLER_87_211 VGND VGND VPWR VPWR sky130_fd_sc_hd__fill_1
XFILLER_87_233 VGND VGND VPWR VPWR sky130_fd_sc_hd__fill_1
XFILLER_85_39 VPWR VGND VPWR VGND sky130_ef_sc_hd__decap_12
XFILLER_18_33 VGND VGND VPWR VPWR sky130_fd_sc_hd__fill_1
XTAP_TAPCELL_ROW_87_1031 VGND VPWR sky130_fd_sc_hd__tapvpwrvgnd_1
XFILLER_18_77 VGND VGND VPWR VPWR sky130_fd_sc_hd__decap_6
XFILLER_70_122 VGND VGND VPWR VPWR sky130_fd_sc_hd__decap_4
XFILLER_51_391 VGND VGND VPWR VPWR sky130_fd_sc_hd__fill_1
XFILLER_78_277 VPWR VGND VPWR VGND sky130_ef_sc_hd__decap_12
XFILLER_93_225 VGND VGND VPWR VPWR sky130_fd_sc_hd__fill_2
XTAP_TAPCELL_ROW_77_935 VGND VPWR sky130_fd_sc_hd__tapvpwrvgnd_1
XFILLER_19_344 VPWR VGND VPWR VGND sky130_ef_sc_hd__decap_12
XFILLER_19_388 VGND VGND VPWR VPWR sky130_fd_sc_hd__decap_4
XFILLER_61_144 VGND VGND VPWR VPWR sky130_fd_sc_hd__fill_1
X_2970_ _0921_ _0922_ _0891_ VGND VGND VPWR VPWR _0923_ sky130_fd_sc_hd__a21o_1
XTAP_TAPCELL_ROW_32_504 VGND VPWR sky130_fd_sc_hd__tapvpwrvgnd_1
XFILLER_91_93 VPWR VGND VPWR VGND sky130_ef_sc_hd__decap_12
XFILLER_30_553 VGND VGND VPWR VPWR sky130_fd_sc_hd__fill_1
XTAP_TAPCELL_ROW_40_581 VGND VPWR sky130_fd_sc_hd__tapvpwrvgnd_1
X_3522_ net96 _1383_ _1416_ VGND VGND VPWR VPWR _0294_ sky130_fd_sc_hd__a21o_1
X_3453_ net132 _1368_ VGND VGND VPWR VPWR _1369_ sky130_fd_sc_hd__nand2_1
X_2404_ _2094_ _2098_ _2097_ VGND VGND VPWR VPWR _2103_ sky130_fd_sc_hd__o21ai_1
X_3384_ net164 net116 net162 net114 VGND VGND VPWR VPWR _1305_ sky130_fd_sc_hd__nand4_1
X_2335_ _2028_ _2032_ _1999_ VGND VGND VPWR VPWR _2034_ sky130_fd_sc_hd__o21ai_1
X_2266_ net263 net212 _1925_ _1964_ VGND VGND VPWR VPWR _1965_ sky130_fd_sc_hd__a31o_1
XFILLER_84_247 VGND VGND VPWR VPWR sky130_fd_sc_hd__decap_4
X_4005_ net362 _1852_ _1854_ VGND VGND VPWR VPWR _0268_ sky130_fd_sc_hd__o21a_1
X_2197_ net417 _1898_ net92 VGND VGND VPWR VPWR _0387_ sky130_fd_sc_hd__mux2_1
XFILLER_65_461 VGND VGND VPWR VPWR sky130_fd_sc_hd__fill_2
XFILLER_80_453 VGND VGND VPWR VPWR sky130_fd_sc_hd__fill_2
XFILLER_21_553 VGND VGND VPWR VPWR sky130_fd_sc_hd__fill_1
XTAP_TAPCELL_ROW_93_1090 VGND VPWR sky130_fd_sc_hd__tapvpwrvgnd_1
XFILLER_88_553 VGND VGND VPWR VPWR sky130_fd_sc_hd__fill_1
XFILLER_88_531 VGND VGND VPWR VPWR sky130_fd_sc_hd__fill_1
Xhold21 systolic_unit_0.U_10.acc_0\[5\] VGND VGND VPWR VPWR net296 sky130_fd_sc_hd__dlygate4sd3_1
Xhold32 systolic_unit_0.U_10.acc_0\[9\] VGND VGND VPWR VPWR net307 sky130_fd_sc_hd__dlygate4sd3_1
XFILLER_48_417 VGND VGND VPWR VPWR sky130_fd_sc_hd__decap_3
XFILLER_75_225 VGND VGND VPWR VPWR sky130_fd_sc_hd__decap_8
Xhold54 net68 VGND VGND VPWR VPWR net329 sky130_fd_sc_hd__dlygate4sd3_1
Xhold43 systolic_unit_0.U_10.acc_1\[8\] VGND VGND VPWR VPWR net318 sky130_fd_sc_hd__dlygate4sd3_1
Xhold65 net62 VGND VGND VPWR VPWR net340 sky130_fd_sc_hd__dlygate4sd3_1
XTAP_TAPCELL_ROW_74_905 VGND VPWR sky130_fd_sc_hd__tapvpwrvgnd_1
Xhold87 matrix_count\[2\] VGND VGND VPWR VPWR net362 sky130_fd_sc_hd__dlygate4sd3_1
Xhold76 net60 VGND VGND VPWR VPWR net351 sky130_fd_sc_hd__dlygate4sd3_1
Xhold98 systolic_unit_0.U_01.acc_1\[1\] VGND VGND VPWR VPWR net373 sky130_fd_sc_hd__dlygate4sd3_1
XFILLER_63_409 VGND VGND VPWR VPWR sky130_fd_sc_hd__fill_2
XFILLER_43_111 VGND VGND VPWR VPWR sky130_fd_sc_hd__fill_1
XTAP_TAPCELL_ROW_82_982 VGND VPWR sky130_fd_sc_hd__tapvpwrvgnd_1
XFILLER_12_553 VGND VGND VPWR VPWR sky130_fd_sc_hd__fill_1
XFILLER_12_531 VGND VGND VPWR VPWR sky130_fd_sc_hd__fill_1
XFILLER_8_513 VPWR VGND VPWR VGND sky130_ef_sc_hd__decap_12
XFILLER_24_391 VPWR VGND VPWR VGND sky130_ef_sc_hd__decap_12
XFILLER_79_553 VGND VGND VPWR VPWR sky130_fd_sc_hd__fill_1
XFILLER_39_439 VGND VGND VPWR VPWR sky130_fd_sc_hd__decap_4
XFILLER_66_236 VGND VGND VPWR VPWR sky130_fd_sc_hd__decap_6
XFILLER_19_163 VGND VGND VPWR VPWR sky130_fd_sc_hd__fill_1
XFILLER_34_166 VPWR VGND VPWR VGND sky130_ef_sc_hd__decap_12
X_2953_ _0871_ _0889_ VGND VGND VPWR VPWR _0906_ sky130_fd_sc_hd__xor2_1
XTAP_TAPCELL_ROW_17_364 VGND VPWR sky130_fd_sc_hd__tapvpwrvgnd_1
X_2884_ _0821_ _0836_ VGND VGND VPWR VPWR _0837_ sky130_fd_sc_hd__or2_1
X_3505_ systolic_unit_0.U_10.acc_1\[13\] net76 net83 systolic_unit_0.U_00.acc_1\[13\]
+ VGND VGND VPWR VPWR _1408_ sky130_fd_sc_hd__a22o_1
X_4485_ clknet_leaf_27_clk net316 _0209_ VGND VGND VPWR VPWR systolic_unit_0.out_acc_0_r1\[0\]
+ sky130_fd_sc_hd__dfrtp_1
X_3436_ net207 net137 VGND VGND VPWR VPWR _1356_ sky130_fd_sc_hd__nor2_4
XFILLER_85_501 VGND VGND VPWR VPWR sky130_fd_sc_hd__decap_3
X_3367_ net161 net114 net112 net163 VGND VGND VPWR VPWR _1288_ sky130_fd_sc_hd__a22o_1
XFILLER_57_225 VPWR VGND VPWR VGND sky130_ef_sc_hd__decap_12
X_2318_ net267 net220 net260 net256 VGND VGND VPWR VPWR _2017_ sky130_fd_sc_hd__nand4_1
X_3298_ _1170_ _1171_ _1173_ VGND VGND VPWR VPWR _1219_ sky130_fd_sc_hd__a21o_1
X_2249_ net216 net261 net256 net220 VGND VGND VPWR VPWR _1948_ sky130_fd_sc_hd__a22o_1
XTAP_TAPCELL_ROW_84_1001 VGND VPWR sky130_fd_sc_hd__tapvpwrvgnd_1
XFILLER_82_29 VPWR VGND VPWR VGND sky130_ef_sc_hd__decap_12
XFILLER_80_294 VGND VGND VPWR VPWR sky130_fd_sc_hd__fill_2
XFILLER_15_34 VGND VGND VPWR VPWR sky130_fd_sc_hd__fill_2
XFILLER_13_328 VGND VGND VPWR VPWR sky130_fd_sc_hd__decap_8
XTAP_TAPCELL_ROW_51_687 VGND VPWR sky130_fd_sc_hd__tapvpwrvgnd_1
XFILLER_5_505 VPWR VGND VPWR VGND sky130_ef_sc_hd__decap_12
Xoutput66 net66 VGND VGND VPWR VPWR D_c_flat[5] sky130_fd_sc_hd__buf_2
XFILLER_0_221 VGND VGND VPWR VPWR sky130_fd_sc_hd__decap_3
Xoutput55 net55 VGND VGND VPWR VPWR D_c_flat[24] sky130_fd_sc_hd__buf_2
Xoutput44 net44 VGND VGND VPWR VPWR D_c_flat[14] sky130_fd_sc_hd__buf_2
XFILLER_76_545 VGND VGND VPWR VPWR sky130_fd_sc_hd__decap_8
XFILLER_48_247 VGND VGND VPWR VPWR sky130_fd_sc_hd__fill_1
XTAP_TAPCELL_ROW_59_765 VGND VPWR sky130_fd_sc_hd__tapvpwrvgnd_1
XFILLER_63_206 VGND VGND VPWR VPWR sky130_fd_sc_hd__decap_4
XFILLER_16_111 VGND VGND VPWR VPWR sky130_fd_sc_hd__fill_2
XFILLER_56_85 VGND VGND VPWR VPWR sky130_fd_sc_hd__fill_2
XTAP_TAPCELL_ROW_14_334 VGND VPWR sky130_fd_sc_hd__tapvpwrvgnd_1
XFILLER_12_361 VGND VGND VPWR VPWR sky130_fd_sc_hd__decap_3
XFILLER_31_169 VPWR VGND VPWR VGND sky130_ef_sc_hd__decap_12
XFILLER_68_6 VGND VGND VPWR VPWR sky130_fd_sc_hd__decap_6
XFILLER_8_365 VGND VGND VPWR VPWR sky130_fd_sc_hd__fill_1
X_4270_ clknet_leaf_20_clk _0251_ _0006_ VGND VGND VPWR VPWR systolic_unit_0.U_11.acc_1\[6\]
+ sky130_fd_sc_hd__dfrtp_1
XFILLER_86_309 VPWR VGND VPWR VGND sky130_ef_sc_hd__decap_12
X_3221_ net162 net103 net101 net164 VGND VGND VPWR VPWR _1142_ sky130_fd_sc_hd__a22o_1
X_3152_ net157 net106 net104 net159 VGND VGND VPWR VPWR _1073_ sky130_fd_sc_hd__a22o_1
X_3083_ systolic_unit_0.U_10.acc_1\[13\] systolic_unit_0.U_10.acc_0\[13\] net136 VGND
+ VGND VPWR VPWR _1004_ sky130_fd_sc_hd__mux2_1
XFILLER_47_291 VPWR VGND VPWR VGND sky130_ef_sc_hd__decap_12
XFILLER_62_261 VGND VGND VPWR VPWR sky130_fd_sc_hd__decap_8
XFILLER_50_445 VPWR VGND VPWR VGND sky130_ef_sc_hd__decap_12
X_3985_ net97 _1821_ _1844_ VGND VGND VPWR VPWR _0247_ sky130_fd_sc_hd__a21o_1
X_2936_ _0882_ _0888_ _0887_ VGND VGND VPWR VPWR _0889_ sky130_fd_sc_hd__a21o_1
XFILLER_10_309 VGND VGND VPWR VPWR sky130_fd_sc_hd__decap_6
XFILLER_50_489 VPWR VGND VPWR VGND sky130_ef_sc_hd__decap_12
X_2867_ _0797_ _0819_ VGND VGND VPWR VPWR _0820_ sky130_fd_sc_hd__or2_1
X_2798_ net126 net124 net169 net168 VGND VGND VPWR VPWR _0751_ sky130_fd_sc_hd__and4_1
XFILLER_89_125 VPWR VGND VPWR VGND sky130_ef_sc_hd__decap_12
X_4468_ clknet_leaf_24_clk net93 _0192_ VGND VGND VPWR VPWR out_c_valid sky130_fd_sc_hd__dfrtp_1
XFILLER_89_169 VPWR VGND VPWR VGND sky130_ef_sc_hd__decap_12
X_3419_ _1165_ _1338_ _1339_ _1163_ VGND VGND VPWR VPWR _1340_ sky130_fd_sc_hd__o31a_1
XTAP_TAPCELL_ROW_90_1060 VGND VPWR sky130_fd_sc_hd__tapvpwrvgnd_1
X_4399_ clknet_leaf_21_clk net125 _0123_ VGND VGND VPWR VPWR systolic_unit_0.U_01.out_b\[3\]
+ sky130_fd_sc_hd__dfrtp_1
XFILLER_45_217 VGND VGND VPWR VPWR sky130_fd_sc_hd__fill_1
XTAP_TAPCELL_ROW_56_735 VGND VPWR sky130_fd_sc_hd__tapvpwrvgnd_1
XFILLER_26_475 VGND VGND VPWR VPWR sky130_fd_sc_hd__fill_1
XTAP_TAPCELL_ROW_11_304 VGND VPWR sky130_fd_sc_hd__tapvpwrvgnd_1
XFILLER_42_65 VGND VGND VPWR VPWR sky130_fd_sc_hd__decap_3
XFILLER_5_324 VPWR VGND VPWR VGND sky130_ef_sc_hd__decap_12
XFILLER_5_357 VGND VGND VPWR VPWR sky130_fd_sc_hd__fill_1
XFILLER_68_309 VGND VGND VPWR VPWR sky130_fd_sc_hd__decap_8
XFILLER_1_541 VPWR VGND VPWR VGND sky130_ef_sc_hd__decap_12
XFILLER_3_15 VPWR VGND VPWR VGND sky130_ef_sc_hd__decap_12
XFILLER_17_420 VPWR VGND VPWR VGND sky130_ef_sc_hd__decap_12
XFILLER_32_445 VGND VGND VPWR VPWR sky130_fd_sc_hd__decap_6
X_3770_ net189 net196 VGND VGND VPWR VPWR _1659_ sky130_fd_sc_hd__nand2_1
XFILLER_32_489 VPWR VGND VPWR VGND sky130_ef_sc_hd__decap_12
X_2721_ _0672_ _0673_ net123 net168 VGND VGND VPWR VPWR _0674_ sky130_fd_sc_hd__and4bb_1
X_2652_ _0603_ _0604_ VGND VGND VPWR VPWR _0605_ sky130_fd_sc_hd__or2_1
XFILLER_8_195 VGND VGND VPWR VPWR sky130_fd_sc_hd__fill_1
X_2583_ _0548_ _0565_ VGND VGND VPWR VPWR _0566_ sky130_fd_sc_hd__xnor2_1
X_4322_ clknet_leaf_3_clk _0303_ _0046_ VGND VGND VPWR VPWR systolic_unit_0.U_10.acc_1\[14\]
+ sky130_fd_sc_hd__dfrtp_1
Xfanout119 systolic_unit_0.U_01.in_b\[6\] VGND VGND VPWR VPWR net119 sky130_fd_sc_hd__buf_2
X_4253_ net247 VGND VGND VPWR VPWR _0234_ sky130_fd_sc_hd__inv_2
Xfanout108 systolic_unit_0.U_10.in_a\[4\] VGND VGND VPWR VPWR net108 sky130_fd_sc_hd__buf_2
X_3204_ _1101_ _1123_ VGND VGND VPWR VPWR _1125_ sky130_fd_sc_hd__xnor2_1
XFILLER_86_139 VGND VGND VPWR VPWR sky130_fd_sc_hd__fill_1
X_4184_ net242 VGND VGND VPWR VPWR _0165_ sky130_fd_sc_hd__inv_2
X_3135_ _1032_ _1054_ VGND VGND VPWR VPWR _1056_ sky130_fd_sc_hd__xnor2_1
X_3066_ net155 net102 _0985_ _0983_ VGND VGND VPWR VPWR _0987_ sky130_fd_sc_hd__a31o_1
XTAP_TAPCELL_ROW_53_705 VGND VPWR sky130_fd_sc_hd__tapvpwrvgnd_1
XFILLER_82_389 VPWR VGND VPWR VGND sky130_ef_sc_hd__decap_12
XFILLER_10_106 VPWR VGND VPWR VGND sky130_ef_sc_hd__decap_12
X_3968_ systolic_unit_0.U_11.acc_1\[10\] net74 net81 systolic_unit_0.U_01.acc_1\[10\]
+ VGND VGND VPWR VPWR _1836_ sky130_fd_sc_hd__a22o_1
XFILLER_50_253 VPWR VGND VPWR VGND sky130_ef_sc_hd__decap_12
X_2919_ _0857_ _0858_ VGND VGND VPWR VPWR _0872_ sky130_fd_sc_hd__xnor2_2
XTAP_TAPCELL_ROW_61_782 VGND VPWR sky130_fd_sc_hd__tapvpwrvgnd_1
X_3899_ net147 systolic_unit_0.U_01.drain_0 VGND VGND VPWR VPWR _1788_ sky130_fd_sc_hd__or2_1
XFILLER_12_57 VPWR VGND VPWR VGND sky130_ef_sc_hd__decap_12
Xhold151 systolic_unit_0.U_00.acc_0\[4\] VGND VGND VPWR VPWR net426 sky130_fd_sc_hd__dlygate4sd3_1
Xhold140 systolic_unit_0.U_01.acc_1\[4\] VGND VGND VPWR VPWR net415 sky130_fd_sc_hd__dlygate4sd3_1
XFILLER_58_342 VPWR VGND VPWR VGND sky130_ef_sc_hd__decap_12
XFILLER_92_109 VPWR VGND VPWR VGND sky130_ef_sc_hd__decap_12
XFILLER_85_161 VGND VGND VPWR VPWR sky130_fd_sc_hd__decap_6
XFILLER_73_301 VPWR VGND VPWR VGND sky130_ef_sc_hd__decap_12
XTAP_TAPCELL_ROW_69_860 VGND VPWR sky130_fd_sc_hd__tapvpwrvgnd_1
XFILLER_73_356 VGND VGND VPWR VPWR sky130_fd_sc_hd__decap_6
XFILLER_14_401 VPWR VGND VPWR VGND sky130_ef_sc_hd__decap_12
XFILLER_26_250 VGND VGND VPWR VPWR sky130_fd_sc_hd__fill_2
XFILLER_61_529 VGND VGND VPWR VPWR sky130_fd_sc_hd__decap_8
XFILLER_14_445 VPWR VGND VPWR VGND sky130_ef_sc_hd__decap_12
XFILLER_5_165 VGND VGND VPWR VPWR sky130_fd_sc_hd__decap_3
XFILLER_1_393 VPWR VGND VPWR VGND sky130_ef_sc_hd__decap_12
XFILLER_32_253 VGND VGND VPWR VPWR sky130_fd_sc_hd__fill_1
X_3822_ _1708_ _1710_ _1705_ VGND VGND VPWR VPWR _1711_ sky130_fd_sc_hd__o21a_1
X_3753_ _1612_ _1639_ VGND VGND VPWR VPWR _1642_ sky130_fd_sc_hd__xnor2_1
X_2704_ _0646_ _0656_ VGND VGND VPWR VPWR _0657_ sky130_fd_sc_hd__or2_1
X_3684_ _1533_ _1572_ VGND VGND VPWR VPWR _1573_ sky130_fd_sc_hd__xnor2_1
XTAP_TAPCELL_ROW_30_487 VGND VPWR sky130_fd_sc_hd__tapvpwrvgnd_1
X_2635_ net100 _0586_ net80 systolic_unit_0.U_00.acc_1\[2\] VGND VGND VPWR VPWR _0355_
+ sky130_fd_sc_hd__a22o_1
X_2566_ _1995_ _1998_ _0549_ VGND VGND VPWR VPWR _0551_ sky130_fd_sc_hd__or3_1
X_4305_ clknet_leaf_22_clk _0286_ _0029_ VGND VGND VPWR VPWR systolic_unit_0.U_11.acc_0\[13\]
+ sky130_fd_sc_hd__dfrtp_1
X_2497_ _0480_ _0481_ _0476_ VGND VGND VPWR VPWR _0482_ sky130_fd_sc_hd__o21ai_1
X_4236_ net227 VGND VGND VPWR VPWR _0217_ sky130_fd_sc_hd__inv_2
X_4167_ net235 VGND VGND VPWR VPWR _0148_ sky130_fd_sc_hd__inv_2
XFILLER_67_150 VGND VGND VPWR VPWR sky130_fd_sc_hd__decap_6
X_3118_ _1036_ _1037_ _1038_ VGND VGND VPWR VPWR _1039_ sky130_fd_sc_hd__nand3_1
XFILLER_55_312 VPWR VGND VPWR VGND sky130_ef_sc_hd__decap_12
XFILLER_67_161 VGND VGND VPWR VPWR sky130_fd_sc_hd__decap_6
XTAP_TAPCELL_ROW_66_830 VGND VPWR sky130_fd_sc_hd__tapvpwrvgnd_1
XFILLER_82_153 VPWR VGND VPWR VGND sky130_ef_sc_hd__decap_12
X_4098_ net245 VGND VGND VPWR VPWR _0079_ sky130_fd_sc_hd__inv_2
XTAP_TAPCELL_ROW_38_565 VGND VPWR sky130_fd_sc_hd__tapvpwrvgnd_1
X_3049_ net95 _0966_ net77 net423 VGND VGND VPWR VPWR _0327_ sky130_fd_sc_hd__a22o_1
XFILLER_82_197 VPWR VGND VPWR VGND sky130_ef_sc_hd__decap_12
XFILLER_90_29 VPWR VGND VPWR VGND sky130_ef_sc_hd__decap_12
XFILLER_23_242 VPWR VGND VPWR VGND sky130_ef_sc_hd__decap_12
XFILLER_23_275 VGND VGND VPWR VPWR sky130_fd_sc_hd__decap_4
XFILLER_23_78 VPWR VGND VPWR VGND sky130_ef_sc_hd__decap_12
XFILLER_48_20 VGND VGND VPWR VPWR sky130_fd_sc_hd__decap_8
XFILLER_48_97 VGND VGND VPWR VPWR sky130_fd_sc_hd__decap_4
XFILLER_0_27 VGND VGND VPWR VPWR sky130_fd_sc_hd__fill_1
XFILLER_34_507 VPWR VGND VPWR VGND sky130_ef_sc_hd__decap_12
XFILLER_46_345 VGND VGND VPWR VPWR sky130_fd_sc_hd__decap_3
XFILLER_64_41 VGND VGND VPWR VPWR sky130_fd_sc_hd__decap_8
XFILLER_61_337 VGND VGND VPWR VPWR sky130_fd_sc_hd__fill_1
XFILLER_64_85 VGND VGND VPWR VPWR sky130_fd_sc_hd__decap_4
XTAP_TAPCELL_ROW_72_888 VGND VPWR sky130_fd_sc_hd__tapvpwrvgnd_1
XFILLER_14_253 VGND VGND VPWR VPWR sky130_fd_sc_hd__decap_3
XFILLER_42_551 VGND VGND VPWR VPWR sky130_fd_sc_hd__decap_3
XFILLER_9_69 VGND VGND VPWR VPWR sky130_fd_sc_hd__decap_8
XFILLER_80_62 VPWR VGND VPWR VGND sky130_ef_sc_hd__decap_12
Xfanout90 systolic_unit_0.drain_valid VGND VGND VPWR VPWR net90 sky130_fd_sc_hd__clkbuf_8
X_2420_ net268 net255 VGND VGND VPWR VPWR _2119_ sky130_fd_sc_hd__and2_1
XFILLER_89_93 VPWR VGND VPWR VGND sky130_ef_sc_hd__decap_12
X_2351_ _2006_ _2038_ _2043_ VGND VGND VPWR VPWR _2050_ sky130_fd_sc_hd__a21o_1
X_2282_ net268 net213 _1966_ _1968_ VGND VGND VPWR VPWR _1981_ sky130_fd_sc_hd__a22o_1
XTAP_TAPCELL_ROW_9_290 VGND VPWR sky130_fd_sc_hd__tapvpwrvgnd_1
XFILLER_29_3 VPWR VGND VPWR VGND sky130_ef_sc_hd__decap_12
XFILLER_49_150 VPWR VGND VPWR VGND sky130_ef_sc_hd__decap_12
X_4021_ net243 VGND VGND VPWR VPWR _0002_ sky130_fd_sc_hd__inv_2
XFILLER_64_120 VPWR VGND VPWR VGND sky130_ef_sc_hd__decap_12
XTAP_TAPCELL_ROW_63_800 VGND VPWR sky130_fd_sc_hd__tapvpwrvgnd_1
XFILLER_64_153 VGND VGND VPWR VPWR sky130_fd_sc_hd__decap_8
XTAP_TAPCELL_ROW_35_535 VGND VPWR sky130_fd_sc_hd__tapvpwrvgnd_1
XFILLER_64_197 VPWR VGND VPWR VGND sky130_ef_sc_hd__decap_12
X_3805_ _1670_ _1693_ VGND VGND VPWR VPWR _1694_ sky130_fd_sc_hd__xor2_2
X_3736_ _1623_ _1624_ VGND VGND VPWR VPWR _1625_ sky130_fd_sc_hd__and2b_1
X_3667_ net200 net198 net181 net180 VGND VGND VPWR VPWR _1556_ sky130_fd_sc_hd__and4_1
X_3598_ _1473_ _1485_ VGND VGND VPWR VPWR _1487_ sky130_fd_sc_hd__xnor2_1
X_2618_ net427 net89 _0588_ net210 VGND VGND VPWR VPWR _0370_ sky130_fd_sc_hd__a22o_1
X_2549_ _0467_ _0523_ _0533_ VGND VGND VPWR VPWR _0534_ sky130_fd_sc_hd__a21o_1
X_4219_ net227 VGND VGND VPWR VPWR _0200_ sky130_fd_sc_hd__inv_2
XFILLER_47_109 VGND VGND VPWR VPWR sky130_fd_sc_hd__decap_3
XFILLER_75_429 VPWR VGND VPWR VGND sky130_ef_sc_hd__decap_12
XTAP_TAPCELL_ROW_87_1032 VGND VPWR sky130_fd_sc_hd__tapvpwrvgnd_1
XFILLER_70_101 VGND VGND VPWR VPWR sky130_fd_sc_hd__fill_1
XFILLER_43_315 VGND VGND VPWR VPWR sky130_fd_sc_hd__fill_2
XFILLER_43_326 VGND VGND VPWR VPWR sky130_fd_sc_hd__fill_2
XFILLER_34_22 VGND VGND VPWR VPWR sky130_fd_sc_hd__decap_6
XFILLER_43_348 VGND VGND VPWR VPWR sky130_fd_sc_hd__decap_8
XFILLER_70_189 VGND VGND VPWR VPWR sky130_fd_sc_hd__decap_6
XFILLER_11_223 VGND VGND VPWR VPWR sky130_fd_sc_hd__fill_1
XFILLER_7_205 VGND VGND VPWR VPWR sky130_fd_sc_hd__fill_1
XFILLER_59_30 VPWR VGND VPWR VGND sky130_ef_sc_hd__decap_12
XTAP_TAPCELL_ROW_6_260 VGND VPWR sky130_fd_sc_hd__tapvpwrvgnd_1
XFILLER_93_237 VGND VGND VPWR VPWR sky130_fd_sc_hd__decap_4
XFILLER_78_289 VPWR VGND VPWR VGND sky130_ef_sc_hd__decap_12
XTAP_TAPCELL_ROW_77_936 VGND VPWR sky130_fd_sc_hd__tapvpwrvgnd_1
XFILLER_66_429 VPWR VGND VPWR VGND sky130_ef_sc_hd__decap_12
XFILLER_19_334 VGND VGND VPWR VPWR sky130_fd_sc_hd__fill_2
XFILLER_46_120 VGND VGND VPWR VPWR sky130_fd_sc_hd__decap_6
XFILLER_74_473 VGND VGND VPWR VPWR sky130_fd_sc_hd__decap_3
XFILLER_19_378 VGND VGND VPWR VPWR sky130_fd_sc_hd__decap_6
XFILLER_46_186 VGND VGND VPWR VPWR sky130_fd_sc_hd__decap_3
XFILLER_61_123 VPWR VGND VPWR VGND sky130_ef_sc_hd__decap_12
XTAP_TAPCELL_ROW_32_505 VGND VPWR sky130_fd_sc_hd__tapvpwrvgnd_1
X_3521_ systolic_unit_0.U_10.acc_1\[5\] net76 net83 systolic_unit_0.U_00.acc_1\[5\]
+ VGND VGND VPWR VPWR _1416_ sky130_fd_sc_hd__a22o_1
XTAP_TAPCELL_ROW_40_582 VGND VPWR sky130_fd_sc_hd__tapvpwrvgnd_1
XFILLER_6_293 VGND VGND VPWR VPWR sky130_fd_sc_hd__fill_1
X_3452_ _1364_ _1367_ VGND VGND VPWR VPWR _1368_ sky130_fd_sc_hd__or2_1
X_3383_ net163 net116 net161 net114 VGND VGND VPWR VPWR _1304_ sky130_fd_sc_hd__and4_1
X_2403_ _2092_ _2101_ _2068_ _2075_ VGND VGND VPWR VPWR _2102_ sky130_fd_sc_hd__o211ai_2
X_2334_ _1999_ _2028_ _2032_ VGND VGND VPWR VPWR _2033_ sky130_fd_sc_hd__nor3_1
X_2265_ net262 net215 net212 net264 VGND VGND VPWR VPWR _1964_ sky130_fd_sc_hd__a22oi_1
XFILLER_69_289 VGND VGND VPWR VPWR sky130_fd_sc_hd__decap_3
X_4004_ matrix_count\[2\] _1852_ _1850_ VGND VGND VPWR VPWR _1854_ sky130_fd_sc_hd__a21boi_1
X_2196_ systolic_unit_0.U_11.acc_0\[2\] systolic_unit_0.U_11.acc_1\[2\] net144 VGND
+ VGND VPWR VPWR _1898_ sky130_fd_sc_hd__mux2_1
XFILLER_92_270 VPWR VGND VPWR VGND sky130_ef_sc_hd__decap_12
XFILLER_1_81 VPWR VGND VPWR VGND sky130_ef_sc_hd__decap_12
XTAP_TAPCELL_ROW_48_660 VGND VPWR sky130_fd_sc_hd__tapvpwrvgnd_1
XFILLER_80_421 VPWR VGND VPWR VGND sky130_ef_sc_hd__decap_12
XFILLER_37_197 VGND VGND VPWR VPWR sky130_fd_sc_hd__decap_3
XFILLER_33_381 VGND VGND VPWR VPWR sky130_fd_sc_hd__decap_8
X_3719_ _1575_ _1605_ VGND VGND VPWR VPWR _1608_ sky130_fd_sc_hd__xnor2_1
XTAP_TAPCELL_ROW_93_1091 VGND VPWR sky130_fd_sc_hd__tapvpwrvgnd_1
Xhold22 systolic_unit_0.U_10.acc_0\[15\] VGND VGND VPWR VPWR net297 sky130_fd_sc_hd__dlygate4sd3_1
Xhold44 systolic_unit_0.U_10.acc_1\[7\] VGND VGND VPWR VPWR net319 sky130_fd_sc_hd__dlygate4sd3_1
XFILLER_29_66 VGND VGND VPWR VPWR sky130_fd_sc_hd__decap_8
Xhold55 net67 VGND VGND VPWR VPWR net330 sky130_fd_sc_hd__dlygate4sd3_1
Xhold33 systolic_unit_0.U_10.acc_1\[0\] VGND VGND VPWR VPWR net308 sky130_fd_sc_hd__dlygate4sd3_1
XTAP_TAPCELL_ROW_74_906 VGND VPWR sky130_fd_sc_hd__tapvpwrvgnd_1
Xhold88 _0268_ VGND VGND VPWR VPWR net363 sky130_fd_sc_hd__dlygate4sd3_1
Xhold77 net50 VGND VGND VPWR VPWR net352 sky130_fd_sc_hd__dlygate4sd3_1
XTAP_TAPCELL_ROW_3_230 VGND VPWR sky130_fd_sc_hd__tapvpwrvgnd_1
Xhold99 systolic_unit_0.U_00.acc_1\[14\] VGND VGND VPWR VPWR net374 sky130_fd_sc_hd__dlygate4sd3_1
Xhold66 net49 VGND VGND VPWR VPWR net341 sky130_fd_sc_hd__dlygate4sd3_1
XFILLER_56_473 VGND VGND VPWR VPWR sky130_fd_sc_hd__decap_3
XFILLER_83_281 VPWR VGND VPWR VGND sky130_ef_sc_hd__decap_12
XFILLER_28_197 VPWR VGND VPWR VGND sky130_ef_sc_hd__decap_12
XTAP_TAPCELL_ROW_82_983 VGND VPWR sky130_fd_sc_hd__tapvpwrvgnd_1
XFILLER_8_525 VGND VGND VPWR VPWR sky130_fd_sc_hd__decap_6
XFILLER_6_15 VPWR VGND VPWR VGND sky130_ef_sc_hd__decap_12
XFILLER_39_407 VGND VGND VPWR VPWR sky130_fd_sc_hd__decap_8
XFILLER_86_83 VGND VGND VPWR VPWR sky130_fd_sc_hd__fill_1
XTAP_TAPCELL_ROW_45_630 VGND VPWR sky130_fd_sc_hd__tapvpwrvgnd_1
XFILLER_62_421 VGND VGND VPWR VPWR sky130_fd_sc_hd__fill_1
XFILLER_34_134 VGND VGND VPWR VPWR sky130_fd_sc_hd__decap_6
X_2952_ _0892_ _0904_ VGND VGND VPWR VPWR _0905_ sky130_fd_sc_hd__nor2_1
XTAP_TAPCELL_ROW_17_365 VGND VPWR sky130_fd_sc_hd__tapvpwrvgnd_1
XFILLER_34_178 VGND VGND VPWR VPWR sky130_fd_sc_hd__decap_6
XFILLER_62_498 VGND VGND VPWR VPWR sky130_fd_sc_hd__fill_1
X_2883_ _0818_ _0820_ VGND VGND VPWR VPWR _0836_ sky130_fd_sc_hd__and2b_1
X_4484_ clknet_leaf_3_clk net302 _0208_ VGND VGND VPWR VPWR systolic_unit_0.out_acc_1_r1\[15\]
+ sky130_fd_sc_hd__dfrtp_1
X_3504_ net300 _1403_ _1405_ net374 _1407_ VGND VGND VPWR VPWR _0303_ sky130_fd_sc_hd__a221o_1
XFILLER_89_329 VGND VGND VPWR VPWR sky130_fd_sc_hd__fill_2
X_3435_ systolic_unit_0.U_00.acc_0\[14\] net206 net136 VGND VGND VPWR VPWR _1355_
+ sky130_fd_sc_hd__a21o_1
X_3366_ net163 net161 net114 net112 VGND VGND VPWR VPWR _1287_ sky130_fd_sc_hd__nand4_2
X_3297_ _1215_ _1216_ _1206_ VGND VGND VPWR VPWR _1218_ sky130_fd_sc_hd__a21o_1
X_2317_ net267 net260 VGND VGND VPWR VPWR _2016_ sky130_fd_sc_hd__nand2_1
XFILLER_57_204 VPWR VGND VPWR VGND sky130_ef_sc_hd__decap_12
X_2248_ net220 net216 net261 net256 VGND VGND VPWR VPWR _1947_ sky130_fd_sc_hd__nand4_1
XFILLER_57_237 VGND VGND VPWR VPWR sky130_fd_sc_hd__decap_4
XFILLER_72_207 VPWR VGND VPWR VGND sky130_ef_sc_hd__decap_12
XTAP_TAPCELL_ROW_0_200 VGND VPWR sky130_fd_sc_hd__tapvpwrvgnd_1
XTAP_TAPCELL_ROW_84_1002 VGND VPWR sky130_fd_sc_hd__tapvpwrvgnd_1
X_2179_ net350 _1889_ net91 VGND VGND VPWR VPWR _0396_ sky130_fd_sc_hd__mux2_1
XFILLER_53_432 VGND VGND VPWR VPWR sky130_fd_sc_hd__fill_2
XFILLER_80_251 VGND VGND VPWR VPWR sky130_fd_sc_hd__fill_1
XFILLER_25_167 VGND VGND VPWR VPWR sky130_fd_sc_hd__fill_1
XFILLER_13_318 VGND VGND VPWR VPWR sky130_fd_sc_hd__fill_1
XTAP_TAPCELL_ROW_51_688 VGND VPWR sky130_fd_sc_hd__tapvpwrvgnd_1
XFILLER_31_23 VPWR VGND VPWR VGND sky130_ef_sc_hd__decap_12
XFILLER_5_517 VPWR VGND VPWR VGND sky130_ef_sc_hd__decap_12
Xoutput45 net45 VGND VGND VPWR VPWR D_c_flat[15] sky130_fd_sc_hd__buf_2
Xoutput67 net67 VGND VGND VPWR VPWR D_c_flat[6] sky130_fd_sc_hd__buf_2
Xoutput56 net56 VGND VGND VPWR VPWR D_c_flat[25] sky130_fd_sc_hd__buf_2
XFILLER_88_362 VGND VGND VPWR VPWR sky130_fd_sc_hd__fill_2
XFILLER_91_505 VPWR VGND VPWR VGND sky130_ef_sc_hd__decap_12
XTAP_TAPCELL_ROW_59_766 VGND VPWR sky130_fd_sc_hd__tapvpwrvgnd_1
XFILLER_31_104 VGND VGND VPWR VPWR sky130_fd_sc_hd__decap_8
XTAP_TAPCELL_ROW_42_600 VGND VPWR sky130_fd_sc_hd__tapvpwrvgnd_1
XFILLER_44_498 VPWR VGND VPWR VGND sky130_ef_sc_hd__decap_12
XTAP_TAPCELL_ROW_14_335 VGND VPWR sky130_fd_sc_hd__tapvpwrvgnd_1
XFILLER_79_351 VPWR VGND VPWR VGND sky130_ef_sc_hd__decap_12
X_3220_ net164 net162 net103 net101 VGND VGND VPWR VPWR _1141_ sky130_fd_sc_hd__nand4_1
X_3151_ net159 net157 net106 net104 VGND VGND VPWR VPWR _1072_ sky130_fd_sc_hd__and4_1
XFILLER_11_3 VPWR VGND VPWR VGND sky130_ef_sc_hd__decap_12
X_3082_ _1001_ _1002_ VGND VGND VPWR VPWR _1003_ sky130_fd_sc_hd__and2_1
XFILLER_47_281 VGND VGND VPWR VPWR sky130_fd_sc_hd__decap_6
XFILLER_50_457 VGND VGND VPWR VPWR sky130_fd_sc_hd__fill_1
X_3984_ systolic_unit_0.U_11.acc_1\[2\] net74 net81 systolic_unit_0.U_01.acc_1\[2\]
+ VGND VGND VPWR VPWR _1844_ sky130_fd_sc_hd__a22o_1
X_2935_ _0872_ _0886_ VGND VGND VPWR VPWR _0888_ sky130_fd_sc_hd__xor2_2
X_2866_ net176 net120 systolic_unit_0.U_01.in_b\[6\] systolic_unit_0.U_00.out_a\[0\]
+ VGND VGND VPWR VPWR _0819_ sky130_fd_sc_hd__a22oi_1
X_2797_ net171 net122 VGND VGND VPWR VPWR _0750_ sky130_fd_sc_hd__nand2_1
XFILLER_89_137 VPWR VGND VPWR VGND sky130_ef_sc_hd__decap_12
X_4467_ clknet_leaf_10_clk _0416_ _0191_ VGND VGND VPWR VPWR net45 sky130_fd_sc_hd__dfrtp_1
X_3418_ _1161_ _1329_ _1200_ _1334_ VGND VGND VPWR VPWR _1339_ sky130_fd_sc_hd__and4_1
X_4398_ clknet_leaf_17_clk net127 _0122_ VGND VGND VPWR VPWR systolic_unit_0.U_01.out_b\[2\]
+ sky130_fd_sc_hd__dfrtp_1
XTAP_TAPCELL_ROW_90_1061 VGND VPWR sky130_fd_sc_hd__tapvpwrvgnd_1
X_3349_ _1229_ _1207_ _1268_ _1269_ VGND VGND VPWR VPWR _1270_ sky130_fd_sc_hd__or4_4
XFILLER_93_29 VPWR VGND VPWR VGND sky130_ef_sc_hd__decap_12
XFILLER_73_505 VPWR VGND VPWR VGND sky130_ef_sc_hd__decap_12
XFILLER_85_398 VPWR VGND VPWR VGND sky130_ef_sc_hd__decap_12
XFILLER_26_23 VGND VGND VPWR VPWR sky130_fd_sc_hd__decap_4
XFILLER_26_421 VGND VGND VPWR VPWR sky130_fd_sc_hd__fill_1
XTAP_TAPCELL_ROW_56_736 VGND VPWR sky130_fd_sc_hd__tapvpwrvgnd_1
XFILLER_41_402 VPWR VGND VPWR VGND sky130_ef_sc_hd__decap_12
XFILLER_41_446 VGND VGND VPWR VPWR sky130_fd_sc_hd__fill_2
XTAP_TAPCELL_ROW_11_305 VGND VPWR sky130_fd_sc_hd__tapvpwrvgnd_1
XFILLER_21_181 VGND VGND VPWR VPWR sky130_fd_sc_hd__fill_1
XFILLER_1_553 VGND VGND VPWR VPWR sky130_fd_sc_hd__fill_1
XFILLER_3_27 VPWR VGND VPWR VGND sky130_ef_sc_hd__decap_12
XFILLER_76_365 VPWR VGND VPWR VGND sky130_ef_sc_hd__decap_12
XFILLER_76_398 VGND VGND VPWR VPWR sky130_fd_sc_hd__decap_4
XFILLER_83_51 VGND VGND VPWR VPWR sky130_fd_sc_hd__decap_4
XFILLER_17_432 VPWR VGND VPWR VGND sky130_ef_sc_hd__decap_12
XTAP_TAPCELL_ROW_27_460 VGND VPWR sky130_fd_sc_hd__tapvpwrvgnd_1
XPHY_EDGE_ROW_17_Left_111 VGND VGND VPWR VPWR sky130_fd_sc_hd__decap_3
X_2720_ net127 net166 _0639_ VGND VGND VPWR VPWR _0673_ sky130_fd_sc_hd__a21oi_1
X_2651_ _0592_ _0593_ _0602_ VGND VGND VPWR VPWR _0604_ sky130_fd_sc_hd__o21ba_1
X_2582_ _0538_ _0552_ _0550_ VGND VGND VPWR VPWR _0565_ sky130_fd_sc_hd__o21a_1
XPHY_EDGE_ROW_26_Left_120 VGND VGND VPWR VPWR sky130_fd_sc_hd__decap_3
X_4321_ clknet_leaf_1_clk _0302_ _0045_ VGND VGND VPWR VPWR systolic_unit_0.U_10.acc_1\[13\]
+ sky130_fd_sc_hd__dfrtp_1
X_4252_ net236 VGND VGND VPWR VPWR _0233_ sky130_fd_sc_hd__inv_2
Xfanout109 systolic_unit_0.U_10.in_a\[3\] VGND VGND VPWR VPWR net109 sky130_fd_sc_hd__buf_2
X_3203_ _1123_ _1101_ VGND VGND VPWR VPWR _1124_ sky130_fd_sc_hd__and2b_1
XFILLER_79_181 VPWR VGND VPWR VGND sky130_ef_sc_hd__decap_12
X_4183_ net250 VGND VGND VPWR VPWR _0164_ sky130_fd_sc_hd__inv_2
X_3134_ _1054_ _1032_ VGND VGND VPWR VPWR _1055_ sky130_fd_sc_hd__nand2b_1
XFILLER_55_505 VGND VGND VPWR VPWR sky130_fd_sc_hd__decap_8
X_3065_ systolic_unit_0.U_00.out_b\[5\] net101 VGND VGND VPWR VPWR _0986_ sky130_fd_sc_hd__nand2_1
XFILLER_82_346 VPWR VGND VPWR VGND sky130_ef_sc_hd__decap_12
XTAP_TAPCELL_ROW_53_706 VGND VPWR sky130_fd_sc_hd__tapvpwrvgnd_1
XFILLER_35_295 VPWR VGND VPWR VGND sky130_ef_sc_hd__decap_12
XFILLER_50_265 VGND VGND VPWR VPWR sky130_fd_sc_hd__decap_8
X_3967_ net98 _1798_ net81 net367 _1835_ VGND VGND VPWR VPWR _0256_ sky130_fd_sc_hd__a221o_1
X_2918_ _0863_ _0864_ VGND VGND VPWR VPWR _0871_ sky130_fd_sc_hd__xor2_1
XFILLER_10_129 VGND VGND VPWR VPWR sky130_fd_sc_hd__decap_8
XFILLER_10_118 VGND VGND VPWR VPWR sky130_fd_sc_hd__fill_1
XTAP_TAPCELL_ROW_61_783 VGND VPWR sky130_fd_sc_hd__tapvpwrvgnd_1
Xclkbuf_leaf_30_clk clknet_2_1__leaf_clk VGND VGND VPWR VPWR clknet_leaf_30_clk sky130_fd_sc_hd__clkbuf_8
X_3898_ net144 systolic_unit_0.U_01.drain_0 VGND VGND VPWR VPWR _1787_ sky130_fd_sc_hd__nor2_1
X_2849_ _0798_ _0800_ VGND VGND VPWR VPWR _0802_ sky130_fd_sc_hd__nor2_1
XFILLER_12_69 VGND VGND VPWR VPWR sky130_fd_sc_hd__decap_4
XFILLER_88_29 VPWR VGND VPWR VGND sky130_ef_sc_hd__decap_12
X_4519_ clknet_leaf_25_clk net15 _0243_ VGND VGND VPWR VPWR systolic_unit_0.U_10.in_a\[6\]
+ sky130_fd_sc_hd__dfrtp_1
Xhold141 systolic_unit_0.U_00.acc_1\[15\] VGND VGND VPWR VPWR net416 sky130_fd_sc_hd__dlygate4sd3_1
Xhold130 systolic_unit_0.U_00.acc_1\[1\] VGND VGND VPWR VPWR net405 sky130_fd_sc_hd__dlygate4sd3_1
Xhold152 systolic_unit_0.U_00.acc_0\[1\] VGND VGND VPWR VPWR net427 sky130_fd_sc_hd__dlygate4sd3_1
XFILLER_58_321 VGND VGND VPWR VPWR sky130_fd_sc_hd__fill_1
XTAP_TAPCELL_ROW_69_861 VGND VPWR sky130_fd_sc_hd__tapvpwrvgnd_1
XFILLER_37_11 VGND VGND VPWR VPWR sky130_fd_sc_hd__decap_4
XFILLER_58_354 VGND VGND VPWR VPWR sky130_fd_sc_hd__decap_8
XFILLER_58_365 VGND VGND VPWR VPWR sky130_fd_sc_hd__decap_8
XFILLER_73_313 VGND VGND VPWR VPWR sky130_fd_sc_hd__decap_6
XFILLER_14_413 VGND VGND VPWR VPWR sky130_fd_sc_hd__decap_6
XFILLER_53_54 VGND VGND VPWR VPWR sky130_fd_sc_hd__fill_2
XFILLER_14_457 VPWR VGND VPWR VGND sky130_ef_sc_hd__decap_12
XTAP_TAPCELL_ROW_24_430 VGND VPWR sky130_fd_sc_hd__tapvpwrvgnd_1
Xclkbuf_leaf_21_clk clknet_2_3__leaf_clk VGND VGND VPWR VPWR clknet_leaf_21_clk sky130_fd_sc_hd__clkbuf_8
XFILLER_5_177 VPWR VGND VPWR VGND sky130_ef_sc_hd__decap_12
XFILLER_49_332 VGND VGND VPWR VPWR sky130_fd_sc_hd__decap_4
XFILLER_37_505 VPWR VGND VPWR VGND sky130_ef_sc_hd__decap_12
XFILLER_17_240 VGND VGND VPWR VPWR sky130_fd_sc_hd__decap_6
X_3821_ net203 _1709_ net188 VGND VGND VPWR VPWR _1710_ sky130_fd_sc_hd__and3_1
XFILLER_9_461 VPWR VGND VPWR VGND sky130_ef_sc_hd__decap_12
X_3752_ _1631_ _1636_ _1635_ VGND VGND VPWR VPWR _1641_ sky130_fd_sc_hd__a21o_1
Xclkbuf_leaf_12_clk clknet_2_2__leaf_clk VGND VGND VPWR VPWR clknet_leaf_12_clk sky130_fd_sc_hd__clkbuf_8
X_2703_ _0651_ _0654_ VGND VGND VPWR VPWR _0656_ sky130_fd_sc_hd__xor2_1
X_3683_ _1570_ _1571_ _1569_ VGND VGND VPWR VPWR _1572_ sky130_fd_sc_hd__a21oi_1
XTAP_TAPCELL_ROW_30_488 VGND VPWR sky130_fd_sc_hd__tapvpwrvgnd_1
X_2634_ net100 _0584_ net79 net414 VGND VGND VPWR VPWR _0356_ sky130_fd_sc_hd__a22o_1
X_2565_ _1995_ _1998_ _0549_ VGND VGND VPWR VPWR _0550_ sky130_fd_sc_hd__o21ai_2
X_4304_ clknet_leaf_16_clk _0285_ _0028_ VGND VGND VPWR VPWR systolic_unit_0.U_11.acc_0\[12\]
+ sky130_fd_sc_hd__dfrtp_1
X_2496_ _0472_ _0475_ VGND VGND VPWR VPWR _0481_ sky130_fd_sc_hd__xnor2_1
XFILLER_87_449 VGND VGND VPWR VPWR sky130_fd_sc_hd__decap_4
X_4235_ net227 VGND VGND VPWR VPWR _0216_ sky130_fd_sc_hd__inv_2
X_4166_ net235 VGND VGND VPWR VPWR _0147_ sky130_fd_sc_hd__inv_2
X_3117_ net109 net154 net152 net111 VGND VGND VPWR VPWR _1038_ sky130_fd_sc_hd__a22o_1
XFILLER_55_324 VGND VGND VPWR VPWR sky130_fd_sc_hd__fill_1
XTAP_TAPCELL_ROW_66_831 VGND VPWR sky130_fd_sc_hd__tapvpwrvgnd_1
XFILLER_82_121 VPWR VGND VPWR VGND sky130_ef_sc_hd__decap_12
XFILLER_55_335 VGND VGND VPWR VPWR sky130_fd_sc_hd__fill_1
XFILLER_55_346 VPWR VGND VPWR VGND sky130_ef_sc_hd__decap_12
X_4097_ net245 VGND VGND VPWR VPWR _0078_ sky130_fd_sc_hd__inv_2
XFILLER_82_165 VPWR VGND VPWR VGND sky130_ef_sc_hd__decap_12
XTAP_TAPCELL_ROW_38_566 VGND VPWR sky130_fd_sc_hd__tapvpwrvgnd_1
X_3048_ net94 _0965_ net77 net392 VGND VGND VPWR VPWR _0328_ sky130_fd_sc_hd__a22o_1
XFILLER_11_405 VPWR VGND VPWR VGND sky130_ef_sc_hd__decap_12
XFILLER_23_254 VPWR VGND VPWR VGND sky130_ef_sc_hd__decap_12
XTAP_TAPCELL_ROW_21_400 VGND VPWR sky130_fd_sc_hd__tapvpwrvgnd_1
XFILLER_11_449 VPWR VGND VPWR VGND sky130_ef_sc_hd__decap_12
XFILLER_19_505 VPWR VGND VPWR VGND sky130_ef_sc_hd__decap_12
XFILLER_34_519 VPWR VGND VPWR VGND sky130_ef_sc_hd__decap_12
XTAP_TAPCELL_ROW_72_889 VGND VPWR sky130_fd_sc_hd__tapvpwrvgnd_1
XFILLER_9_15 VPWR VGND VPWR VGND sky130_ef_sc_hd__decap_12
XFILLER_80_41 VGND VGND VPWR VPWR sky130_fd_sc_hd__fill_2
XFILLER_80_74 VGND VGND VPWR VPWR sky130_fd_sc_hd__decap_6
Xfanout80 _0590_ VGND VGND VPWR VPWR net80 sky130_fd_sc_hd__clkbuf_2
Xfanout91 net92 VGND VGND VPWR VPWR net91 sky130_fd_sc_hd__clkbuf_4
XFILLER_6_475 VGND VGND VPWR VPWR sky130_fd_sc_hd__fill_1
XFILLER_69_416 VGND VGND VPWR VPWR sky130_fd_sc_hd__fill_1
X_2350_ _2045_ _2048_ VGND VGND VPWR VPWR _2049_ sky130_fd_sc_hd__xor2_1
X_2281_ _1973_ _1979_ VGND VGND VPWR VPWR _1980_ sky130_fd_sc_hd__nor2_1
XFILLER_69_449 VPWR VGND VPWR VGND sky130_ef_sc_hd__decap_12
XTAP_TAPCELL_ROW_9_291 VGND VPWR sky130_fd_sc_hd__tapvpwrvgnd_1
Xclkbuf_leaf_1_clk clknet_2_0__leaf_clk VGND VGND VPWR VPWR clknet_leaf_1_clk sky130_fd_sc_hd__clkbuf_8
X_4020_ net246 VGND VGND VPWR VPWR _0001_ sky130_fd_sc_hd__inv_2
XFILLER_49_162 VGND VGND VPWR VPWR sky130_fd_sc_hd__decap_6
XFILLER_49_173 VPWR VGND VPWR VGND sky130_ef_sc_hd__decap_12
XFILLER_64_132 VGND VGND VPWR VPWR sky130_fd_sc_hd__decap_8
XTAP_TAPCELL_ROW_63_801 VGND VPWR sky130_fd_sc_hd__tapvpwrvgnd_1
XTAP_TAPCELL_ROW_35_536 VGND VPWR sky130_fd_sc_hd__tapvpwrvgnd_1
X_3804_ _1691_ _1692_ _1687_ VGND VGND VPWR VPWR _1693_ sky130_fd_sc_hd__o21ai_2
X_3735_ net198 net183 net196 net185 VGND VGND VPWR VPWR _1624_ sky130_fd_sc_hd__a22o_1
X_3666_ _1536_ _1554_ VGND VGND VPWR VPWR _1555_ sky130_fd_sc_hd__nor2_1
X_3597_ _1453_ _1473_ _1484_ VGND VGND VPWR VPWR _1486_ sky130_fd_sc_hd__or3_1
X_2617_ _0513_ _0587_ VGND VGND VPWR VPWR _0588_ sky130_fd_sc_hd__nor2_1
X_2548_ _0529_ _0532_ VGND VGND VPWR VPWR _0533_ sky130_fd_sc_hd__nand2_1
X_4218_ net222 VGND VGND VPWR VPWR _0199_ sky130_fd_sc_hd__inv_2
X_2479_ _0458_ _0462_ _0463_ VGND VGND VPWR VPWR _0464_ sky130_fd_sc_hd__or3_1
XFILLER_28_313 VGND VGND VPWR VPWR sky130_fd_sc_hd__fill_1
X_4149_ net234 VGND VGND VPWR VPWR _0130_ sky130_fd_sc_hd__inv_2
XFILLER_83_463 VPWR VGND VPWR VGND sky130_ef_sc_hd__decap_12
XFILLER_55_198 VPWR VGND VPWR VGND sky130_ef_sc_hd__decap_12
XFILLER_51_371 VPWR VGND VPWR VGND sky130_ef_sc_hd__decap_12
XFILLER_51_393 VGND VGND VPWR VPWR sky130_fd_sc_hd__fill_1
Xclkload0 clknet_2_0__leaf_clk VGND VGND VPWR VPWR clkload0/X sky130_fd_sc_hd__clkbuf_4
XFILLER_59_42 VPWR VGND VPWR VGND sky130_ef_sc_hd__decap_12
XFILLER_59_75 VPWR VGND VPWR VGND sky130_ef_sc_hd__decap_12
XTAP_TAPCELL_ROW_6_261 VGND VPWR sky130_fd_sc_hd__tapvpwrvgnd_1
XFILLER_66_419 VGND VGND VPWR VPWR sky130_fd_sc_hd__fill_1
XFILLER_93_205 VGND VGND VPWR VPWR sky130_fd_sc_hd__fill_1
XTAP_TAPCELL_ROW_77_937 VGND VPWR sky130_fd_sc_hd__tapvpwrvgnd_1
Xfanout270 net271 VGND VGND VPWR VPWR net270 sky130_fd_sc_hd__buf_2
XFILLER_75_63 VGND VGND VPWR VPWR sky130_fd_sc_hd__fill_1
XFILLER_61_113 VGND VGND VPWR VPWR sky130_fd_sc_hd__decap_6
XFILLER_61_135 VGND VGND VPWR VPWR sky130_fd_sc_hd__fill_2
XFILLER_91_51 VGND VGND VPWR VPWR sky130_fd_sc_hd__decap_4
XFILLER_15_541 VPWR VGND VPWR VGND sky130_ef_sc_hd__decap_12
XTAP_TAPCELL_ROW_32_506 VGND VPWR sky130_fd_sc_hd__tapvpwrvgnd_1
XFILLER_42_382 VGND VGND VPWR VPWR sky130_fd_sc_hd__fill_1
XFILLER_30_533 VPWR VGND VPWR VGND sky130_ef_sc_hd__decap_12
X_3520_ net312 net76 net83 net395 _1415_ VGND VGND VPWR VPWR _0295_ sky130_fd_sc_hd__a221o_1
XTAP_TAPCELL_ROW_40_583 VGND VPWR sky130_fd_sc_hd__tapvpwrvgnd_1
X_3451_ _1161_ _1336_ _1337_ VGND VGND VPWR VPWR _1367_ sky130_fd_sc_hd__nor3_1
X_3382_ _1292_ _1295_ _1294_ VGND VGND VPWR VPWR _1303_ sky130_fd_sc_hd__a21o_1
X_2402_ _2092_ _2100_ _2099_ VGND VGND VPWR VPWR _2101_ sky130_fd_sc_hd__nor3b_2
X_2333_ _2031_ _2029_ VGND VGND VPWR VPWR _2032_ sky130_fd_sc_hd__and2b_1
X_2264_ _1926_ _1927_ VGND VGND VPWR VPWR _1963_ sky130_fd_sc_hd__xor2_1
XFILLER_69_279 VGND VGND VPWR VPWR sky130_fd_sc_hd__fill_1
X_4003_ _1852_ _1853_ VGND VGND VPWR VPWR _0267_ sky130_fd_sc_hd__nor2_1
X_2195_ net341 _1897_ net92 VGND VGND VPWR VPWR _0388_ sky130_fd_sc_hd__mux2_1
XFILLER_80_400 VGND VGND VPWR VPWR sky130_fd_sc_hd__fill_1
XPHY_EDGE_ROW_9_Left_103 VGND VGND VPWR VPWR sky130_fd_sc_hd__decap_3
XFILLER_37_143 VPWR VGND VPWR VGND sky130_ef_sc_hd__decap_12
XTAP_TAPCELL_ROW_48_661 VGND VPWR sky130_fd_sc_hd__tapvpwrvgnd_1
XFILLER_92_282 VPWR VGND VPWR VGND sky130_ef_sc_hd__decap_12
XFILLER_80_433 VPWR VGND VPWR VGND sky130_ef_sc_hd__decap_12
XFILLER_1_93 VPWR VGND VPWR VGND sky130_ef_sc_hd__decap_12
XFILLER_52_168 VGND VGND VPWR VPWR sky130_fd_sc_hd__decap_6
X_3718_ _1597_ _1602_ _1601_ VGND VGND VPWR VPWR _1607_ sky130_fd_sc_hd__a21bo_1
X_3649_ _1503_ _1537_ VGND VGND VPWR VPWR _1538_ sky130_fd_sc_hd__nor2_1
XTAP_TAPCELL_ROW_93_1092 VGND VPWR sky130_fd_sc_hd__tapvpwrvgnd_1
XTAP_TAPCELL_ROW_93_1081 VGND VPWR sky130_fd_sc_hd__tapvpwrvgnd_1
XFILLER_88_533 VPWR VGND VPWR VGND sky130_ef_sc_hd__decap_12
Xhold23 systolic_unit_0.U_10.acc_0\[13\] VGND VGND VPWR VPWR net298 sky130_fd_sc_hd__dlygate4sd3_1
Xhold34 systolic_unit_0.U_10.acc_0\[8\] VGND VGND VPWR VPWR net309 sky130_fd_sc_hd__dlygate4sd3_1
Xhold45 systolic_unit_0.U_10.acc_1\[2\] VGND VGND VPWR VPWR net320 sky130_fd_sc_hd__dlygate4sd3_1
Xhold56 net42 VGND VGND VPWR VPWR net331 sky130_fd_sc_hd__dlygate4sd3_1
XTAP_TAPCELL_ROW_74_907 VGND VPWR sky130_fd_sc_hd__tapvpwrvgnd_1
XTAP_TAPCELL_ROW_3_231 VGND VPWR sky130_fd_sc_hd__tapvpwrvgnd_1
Xhold78 net46 VGND VGND VPWR VPWR net353 sky130_fd_sc_hd__dlygate4sd3_1
Xhold67 net56 VGND VGND VPWR VPWR net342 sky130_fd_sc_hd__dlygate4sd3_1
Xhold89 systolic_unit_0.U_01.acc_1\[14\] VGND VGND VPWR VPWR net364 sky130_fd_sc_hd__dlygate4sd3_1
XFILLER_16_305 VGND VGND VPWR VPWR sky130_fd_sc_hd__decap_3
XFILLER_83_293 VPWR VGND VPWR VGND sky130_ef_sc_hd__decap_12
XFILLER_16_338 VPWR VGND VPWR VGND sky130_ef_sc_hd__decap_12
XFILLER_43_113 VPWR VGND VPWR VGND sky130_ef_sc_hd__decap_12
XFILLER_56_485 VGND VGND VPWR VPWR sky130_fd_sc_hd__fill_2
XFILLER_43_157 VGND VGND VPWR VPWR sky130_fd_sc_hd__decap_8
XTAP_TAPCELL_ROW_82_984 VGND VPWR sky130_fd_sc_hd__tapvpwrvgnd_1
XFILLER_12_533 VPWR VGND VPWR VGND sky130_ef_sc_hd__decap_12
XFILLER_6_27 VGND VGND VPWR VPWR sky130_fd_sc_hd__fill_1
XFILLER_79_500 VGND VGND VPWR VPWR sky130_fd_sc_hd__decap_4
XTAP_TAPCELL_ROW_45_631 VGND VPWR sky130_fd_sc_hd__tapvpwrvgnd_1
X_2951_ _0902_ _0903_ VGND VGND VPWR VPWR _0904_ sky130_fd_sc_hd__nand2_1
XTAP_TAPCELL_ROW_17_366 VGND VPWR sky130_fd_sc_hd__tapvpwrvgnd_1
XFILLER_15_393 VPWR VGND VPWR VGND sky130_ef_sc_hd__decap_12
XFILLER_89_3 VPWR VGND VPWR VGND sky130_ef_sc_hd__decap_12
X_2882_ _0823_ _0834_ VGND VGND VPWR VPWR _0835_ sky130_fd_sc_hd__or2_1
XFILLER_30_363 VGND VGND VPWR VPWR sky130_fd_sc_hd__fill_1
X_3503_ net133 _1353_ VGND VGND VPWR VPWR _1407_ sky130_fd_sc_hd__nor2_1
X_4483_ clknet_leaf_3_clk net300 _0207_ VGND VGND VPWR VPWR systolic_unit_0.out_acc_1_r1\[14\]
+ sky130_fd_sc_hd__dfrtp_1
X_3434_ net134 _1353_ VGND VGND VPWR VPWR _1354_ sky130_fd_sc_hd__nand2_1
X_3365_ _1272_ _1273_ _1262_ VGND VGND VPWR VPWR _1286_ sky130_fd_sc_hd__a21oi_1
X_2316_ _1989_ _2001_ _2014_ VGND VGND VPWR VPWR _2015_ sky130_fd_sc_hd__nand3_1
X_3296_ _1206_ _1215_ _1216_ VGND VGND VPWR VPWR _1217_ sky130_fd_sc_hd__nand3_2
XFILLER_57_216 VGND VGND VPWR VPWR sky130_fd_sc_hd__fill_1
X_2247_ _1942_ _1945_ _1923_ VGND VGND VPWR VPWR _1946_ sky130_fd_sc_hd__a21boi_1
XFILLER_72_219 VPWR VGND VPWR VGND sky130_ef_sc_hd__decap_12
XTAP_TAPCELL_ROW_0_201 VGND VPWR sky130_fd_sc_hd__tapvpwrvgnd_1
XTAP_TAPCELL_ROW_84_1003 VGND VPWR sky130_fd_sc_hd__tapvpwrvgnd_1
XFILLER_25_102 VGND VGND VPWR VPWR sky130_fd_sc_hd__decap_8
XFILLER_25_113 VPWR VGND VPWR VGND sky130_ef_sc_hd__decap_12
X_2178_ systolic_unit_0.U_11.acc_0\[11\] systolic_unit_0.U_11.acc_1\[11\] net148 VGND
+ VGND VPWR VPWR _1889_ sky130_fd_sc_hd__mux2_1
XFILLER_53_400 VGND VGND VPWR VPWR sky130_fd_sc_hd__fill_1
XFILLER_21_352 VGND VGND VPWR VPWR sky130_fd_sc_hd__fill_2
XTAP_TAPCELL_ROW_51_689 VGND VPWR sky130_fd_sc_hd__tapvpwrvgnd_1
XFILLER_31_35 VGND VGND VPWR VPWR sky130_fd_sc_hd__decap_6
XFILLER_5_529 VPWR VGND VPWR VGND sky130_ef_sc_hd__decap_12
XFILLER_31_57 VPWR VGND VPWR VGND sky130_ef_sc_hd__decap_12
Xoutput57 net57 VGND VGND VPWR VPWR D_c_flat[26] sky130_fd_sc_hd__buf_2
Xoutput46 net46 VGND VGND VPWR VPWR D_c_flat[16] sky130_fd_sc_hd__buf_2
Xoutput68 net68 VGND VGND VPWR VPWR D_c_flat[7] sky130_fd_sc_hd__buf_2
XFILLER_0_245 VGND VGND VPWR VPWR sky130_fd_sc_hd__decap_3
XFILLER_0_267 VGND VGND VPWR VPWR sky130_fd_sc_hd__fill_2
XFILLER_56_32 VGND VGND VPWR VPWR sky130_fd_sc_hd__fill_1
XFILLER_91_517 VPWR VGND VPWR VGND sky130_ef_sc_hd__decap_12
XFILLER_29_496 VGND VGND VPWR VPWR sky130_fd_sc_hd__fill_1
XFILLER_56_98 VPWR VGND VPWR VGND sky130_ef_sc_hd__decap_12
XFILLER_71_241 VPWR VGND VPWR VGND sky130_ef_sc_hd__decap_12
XPHY_EDGE_ROW_19_Right_19 VGND VGND VPWR VPWR sky130_fd_sc_hd__decap_3
XFILLER_71_274 VGND VGND VPWR VPWR sky130_fd_sc_hd__decap_6
XTAP_TAPCELL_ROW_42_601 VGND VPWR sky130_fd_sc_hd__tapvpwrvgnd_1
XFILLER_44_477 VGND VGND VPWR VPWR sky130_fd_sc_hd__fill_1
XFILLER_72_75 VGND VGND VPWR VPWR sky130_fd_sc_hd__fill_1
XTAP_TAPCELL_ROW_14_336 VGND VPWR sky130_fd_sc_hd__tapvpwrvgnd_1
XFILLER_12_341 VPWR VGND VPWR VGND sky130_ef_sc_hd__decap_12
XFILLER_8_334 VGND VGND VPWR VPWR sky130_fd_sc_hd__fill_2
XFILLER_8_356 VGND VGND VPWR VPWR sky130_fd_sc_hd__fill_1
XPHY_EDGE_ROW_28_Right_28 VGND VGND VPWR VPWR sky130_fd_sc_hd__decap_3
XFILLER_79_363 VGND VGND VPWR VPWR sky130_fd_sc_hd__decap_8
XFILLER_67_503 VGND VGND VPWR VPWR sky130_fd_sc_hd__fill_1
X_3150_ _1039_ _1065_ _1070_ VGND VGND VPWR VPWR _1071_ sky130_fd_sc_hd__and3_1
X_3081_ _0994_ _1000_ VGND VGND VPWR VPWR _1002_ sky130_fd_sc_hd__or2_1
XPHY_EDGE_ROW_37_Right_37 VGND VGND VPWR VPWR sky130_fd_sc_hd__decap_3
X_3983_ net97 _1819_ _1843_ VGND VGND VPWR VPWR _0248_ sky130_fd_sc_hd__a21o_1
XFILLER_62_285 VPWR VGND VPWR VGND sky130_ef_sc_hd__decap_12
X_2934_ _0872_ _0886_ VGND VGND VPWR VPWR _0887_ sky130_fd_sc_hd__nor2_1
X_2865_ net176 net122 _0816_ _0814_ VGND VGND VPWR VPWR _0818_ sky130_fd_sc_hd__a31o_1
XPHY_EDGE_ROW_46_Right_46 VGND VGND VPWR VPWR sky130_fd_sc_hd__decap_3
X_2796_ _0742_ _0748_ VGND VGND VPWR VPWR _0749_ sky130_fd_sc_hd__nand2_1
XFILLER_7_81 VPWR VGND VPWR VGND sky130_ef_sc_hd__decap_12
XFILLER_89_105 VGND VGND VPWR VPWR sky130_fd_sc_hd__decap_6
X_4466_ clknet_leaf_0_clk _0415_ _0190_ VGND VGND VPWR VPWR net44 sky130_fd_sc_hd__dfrtp_1
XFILLER_89_149 VPWR VGND VPWR VGND sky130_ef_sc_hd__decap_12
X_3417_ _1161_ _1337_ _1160_ VGND VGND VPWR VPWR _1338_ sky130_fd_sc_hd__a21o_1
X_4397_ clknet_leaf_19_clk net129 _0121_ VGND VGND VPWR VPWR systolic_unit_0.U_01.out_b\[1\]
+ sky130_fd_sc_hd__dfrtp_1
X_3348_ _1226_ _1227_ _1228_ VGND VGND VPWR VPWR _1269_ sky130_fd_sc_hd__a21oi_1
XFILLER_73_517 VPWR VGND VPWR VGND sky130_ef_sc_hd__decap_12
X_3279_ _1195_ _1197_ VGND VGND VPWR VPWR _1200_ sky130_fd_sc_hd__xor2_1
XPHY_EDGE_ROW_55_Right_55 VGND VGND VPWR VPWR sky130_fd_sc_hd__decap_3
XFILLER_26_400 VGND VGND VPWR VPWR sky130_fd_sc_hd__decap_6
XTAP_TAPCELL_ROW_56_737 VGND VPWR sky130_fd_sc_hd__tapvpwrvgnd_1
XFILLER_26_466 VGND VGND VPWR VPWR sky130_fd_sc_hd__fill_1
XFILLER_26_477 VPWR VGND VPWR VGND sky130_ef_sc_hd__decap_12
XFILLER_41_414 VPWR VGND VPWR VGND sky130_ef_sc_hd__decap_12
XFILLER_13_127 VPWR VGND VPWR VGND sky130_ef_sc_hd__decap_12
XFILLER_53_285 VGND VGND VPWR VPWR sky130_fd_sc_hd__fill_1
XFILLER_42_23 VGND VGND VPWR VPWR sky130_fd_sc_hd__decap_4
XTAP_TAPCELL_ROW_11_306 VGND VPWR sky130_fd_sc_hd__tapvpwrvgnd_1
XPHY_EDGE_ROW_64_Right_64 VGND VGND VPWR VPWR sky130_fd_sc_hd__decap_3
XFILLER_5_337 VPWR VGND VPWR VGND sky130_ef_sc_hd__decap_12
XFILLER_3_39 VPWR VGND VPWR VGND sky130_ef_sc_hd__decap_12
XFILLER_49_503 VGND VGND VPWR VPWR sky130_fd_sc_hd__fill_1
XPHY_EDGE_ROW_73_Right_73 VGND VGND VPWR VPWR sky130_fd_sc_hd__decap_3
XFILLER_76_377 VGND VGND VPWR VPWR sky130_fd_sc_hd__fill_2
XFILLER_17_444 VGND VGND VPWR VPWR sky130_fd_sc_hd__decap_4
XTAP_TAPCELL_ROW_27_461 VGND VPWR sky130_fd_sc_hd__tapvpwrvgnd_1
XFILLER_44_285 VGND VGND VPWR VPWR sky130_fd_sc_hd__fill_1
XPHY_EDGE_ROW_82_Right_82 VGND VGND VPWR VPWR sky130_fd_sc_hd__decap_3
XFILLER_73_6 VGND VGND VPWR VPWR sky130_fd_sc_hd__decap_8
X_2650_ _0592_ _0602_ net165 net117 VGND VGND VPWR VPWR _0603_ sky130_fd_sc_hd__and4b_1
XFILLER_8_197 VGND VGND VPWR VPWR sky130_fd_sc_hd__decap_6
X_2581_ net356 net89 _0564_ net211 VGND VGND VPWR VPWR _0383_ sky130_fd_sc_hd__a22o_1
X_4320_ clknet_leaf_1_clk _0301_ _0044_ VGND VGND VPWR VPWR systolic_unit_0.U_10.acc_1\[12\]
+ sky130_fd_sc_hd__dfrtp_1
X_4251_ net235 VGND VGND VPWR VPWR _0232_ sky130_fd_sc_hd__inv_2
XPHY_EDGE_ROW_91_Right_91 VGND VGND VPWR VPWR sky130_fd_sc_hd__decap_3
X_3202_ _1102_ _1121_ VGND VGND VPWR VPWR _1123_ sky130_fd_sc_hd__xnor2_1
XFILLER_79_193 VPWR VGND VPWR VGND sky130_ef_sc_hd__decap_12
X_4182_ net250 VGND VGND VPWR VPWR _0163_ sky130_fd_sc_hd__inv_2
X_3133_ _1050_ _1051_ _1053_ _1048_ VGND VGND VPWR VPWR _1054_ sky130_fd_sc_hd__a31oi_1
X_3064_ _0978_ _0984_ _0983_ VGND VGND VPWR VPWR _0985_ sky130_fd_sc_hd__o21ba_1
XFILLER_82_358 VGND VGND VPWR VPWR sky130_fd_sc_hd__decap_6
XTAP_TAPCELL_ROW_53_707 VGND VPWR sky130_fd_sc_hd__tapvpwrvgnd_1
XFILLER_23_447 VGND VGND VPWR VPWR sky130_fd_sc_hd__fill_1
X_3966_ systolic_unit_0.U_01.drain_1 net147 systolic_unit_0.U_11.acc_1\[11\] VGND
+ VGND VPWR VPWR _1835_ sky130_fd_sc_hd__and3b_1
X_2917_ _0862_ _0867_ VGND VGND VPWR VPWR _0870_ sky130_fd_sc_hd__xnor2_1
XTAP_TAPCELL_ROW_61_784 VGND VPWR sky130_fd_sc_hd__tapvpwrvgnd_1
X_3897_ systolic_unit_0.U_01.acc_0\[15\] _1785_ VGND VGND VPWR VPWR _1786_ sky130_fd_sc_hd__or2_1
X_2848_ _0798_ _0800_ VGND VGND VPWR VPWR _0801_ sky130_fd_sc_hd__and2_1
X_2779_ _0731_ _0700_ VGND VGND VPWR VPWR _0732_ sky130_fd_sc_hd__and2b_1
X_4518_ clknet_leaf_24_clk net14 _0242_ VGND VGND VPWR VPWR systolic_unit_0.U_10.in_a\[5\]
+ sky130_fd_sc_hd__dfrtp_1
XFILLER_2_307 VGND VGND VPWR VPWR sky130_fd_sc_hd__fill_1
XFILLER_2_329 VPWR VGND VPWR VGND sky130_ef_sc_hd__decap_12
Xhold120 systolic_unit_0.U_00.acc_1\[6\] VGND VGND VPWR VPWR net395 sky130_fd_sc_hd__dlygate4sd3_1
Xhold131 systolic_unit_0.U_11.acc_0\[9\] VGND VGND VPWR VPWR net406 sky130_fd_sc_hd__dlygate4sd3_1
Xhold153 net45 VGND VGND VPWR VPWR net428 sky130_fd_sc_hd__dlygate4sd3_1
Xhold142 net48 VGND VGND VPWR VPWR net417 sky130_fd_sc_hd__dlygate4sd3_1
X_4449_ clknet_leaf_5_clk net261 _0173_ VGND VGND VPWR VPWR systolic_unit_0.U_00.out_b\[5\]
+ sky130_fd_sc_hd__dfrtp_1
XFILLER_58_377 VPWR VGND VPWR VGND sky130_ef_sc_hd__decap_12
XFILLER_37_89 VGND VGND VPWR VPWR sky130_fd_sc_hd__decap_3
XFILLER_26_296 VPWR VGND VPWR VGND sky130_ef_sc_hd__decap_12
XFILLER_14_469 VGND VGND VPWR VPWR sky130_fd_sc_hd__decap_6
XTAP_TAPCELL_ROW_24_431 VGND VPWR sky130_fd_sc_hd__tapvpwrvgnd_1
XFILLER_41_277 VGND VGND VPWR VPWR sky130_fd_sc_hd__decap_3
XFILLER_53_99 VPWR VGND VPWR VGND sky130_ef_sc_hd__decap_12
XFILLER_5_101 VGND VGND VPWR VPWR sky130_fd_sc_hd__decap_8
XFILLER_5_189 VGND VGND VPWR VPWR sky130_fd_sc_hd__decap_6
XFILLER_78_41 VGND VGND VPWR VPWR sky130_fd_sc_hd__decap_4
XFILLER_78_85 VGND VGND VPWR VPWR sky130_fd_sc_hd__decap_8
XFILLER_78_74 VGND VGND VPWR VPWR sky130_fd_sc_hd__decap_8
XFILLER_89_480 VPWR VGND VPWR VGND sky130_ef_sc_hd__decap_12
XFILLER_49_311 VGND VGND VPWR VPWR sky130_fd_sc_hd__fill_1
XFILLER_76_141 VGND VGND VPWR VPWR sky130_fd_sc_hd__fill_1
XFILLER_91_111 VGND VGND VPWR VPWR sky130_fd_sc_hd__fill_1
XFILLER_37_517 VGND VGND VPWR VPWR sky130_fd_sc_hd__decap_3
XFILLER_49_377 VGND VGND VPWR VPWR sky130_fd_sc_hd__fill_1
XFILLER_52_509 VGND VGND VPWR VPWR sky130_fd_sc_hd__decap_3
XFILLER_17_252 VGND VGND VPWR VPWR sky130_fd_sc_hd__decap_8
X_3820_ _1706_ _1707_ VGND VGND VPWR VPWR _1709_ sky130_fd_sc_hd__xnor2_2
XFILLER_60_553 VGND VGND VPWR VPWR sky130_fd_sc_hd__fill_1
X_3751_ _1639_ _1612_ VGND VGND VPWR VPWR _1640_ sky130_fd_sc_hd__nand2b_1
X_2702_ _0654_ _0651_ VGND VGND VPWR VPWR _0655_ sky130_fd_sc_hd__nand2b_1
XFILLER_9_473 VPWR VGND VPWR VGND sky130_ef_sc_hd__decap_12
X_3682_ _1535_ _1568_ VGND VGND VPWR VPWR _1571_ sky130_fd_sc_hd__xnor2_1
XTAP_TAPCELL_ROW_30_489 VGND VPWR sky130_fd_sc_hd__tapvpwrvgnd_1
X_2633_ net99 _0583_ net79 net410 VGND VGND VPWR VPWR _0357_ sky130_fd_sc_hd__a22o_1
X_2564_ _1960_ _0543_ VGND VGND VPWR VPWR _0549_ sky130_fd_sc_hd__xnor2_1
X_4303_ clknet_leaf_17_clk _0284_ _0027_ VGND VGND VPWR VPWR systolic_unit_0.U_11.acc_0\[11\]
+ sky130_fd_sc_hd__dfrtp_1
X_2495_ _0478_ _0479_ VGND VGND VPWR VPWR _0480_ sky130_fd_sc_hd__nand2_1
X_4234_ net222 VGND VGND VPWR VPWR _0215_ sky130_fd_sc_hd__inv_2
X_4165_ net235 VGND VGND VPWR VPWR _0146_ sky130_fd_sc_hd__inv_2
X_3116_ net107 net155 VGND VGND VPWR VPWR _1037_ sky130_fd_sc_hd__and2_1
XFILLER_82_133 VGND VGND VPWR VPWR sky130_fd_sc_hd__decap_6
X_4096_ net244 VGND VGND VPWR VPWR _0077_ sky130_fd_sc_hd__inv_2
XTAP_TAPCELL_ROW_66_832 VGND VPWR sky130_fd_sc_hd__tapvpwrvgnd_1
XFILLER_55_358 VGND VGND VPWR VPWR sky130_fd_sc_hd__fill_1
XFILLER_82_177 VGND VGND VPWR VPWR sky130_fd_sc_hd__decap_6
XTAP_TAPCELL_ROW_38_567 VGND VPWR sky130_fd_sc_hd__tapvpwrvgnd_1
X_3047_ net94 _0964_ net78 net411 VGND VGND VPWR VPWR _0329_ sky130_fd_sc_hd__a22o_1
XFILLER_23_211 VPWR VGND VPWR VGND sky130_ef_sc_hd__decap_12
XFILLER_63_391 VGND VGND VPWR VPWR sky130_fd_sc_hd__fill_1
XFILLER_51_542 VGND VGND VPWR VPWR sky130_fd_sc_hd__fill_1
XFILLER_11_417 VPWR VGND VPWR VGND sky130_ef_sc_hd__decap_12
XTAP_TAPCELL_ROW_21_401 VGND VPWR sky130_fd_sc_hd__tapvpwrvgnd_1
XFILLER_23_266 VGND VGND VPWR VPWR sky130_fd_sc_hd__decap_3
X_3949_ net145 _1748_ _1823_ VGND VGND VPWR VPWR _1824_ sky130_fd_sc_hd__and3_1
XFILLER_58_141 VPWR VGND VPWR VGND sky130_ef_sc_hd__decap_12
XFILLER_19_517 VPWR VGND VPWR VGND sky130_ef_sc_hd__decap_12
XPHY_EDGE_ROW_45_Left_139 VGND VGND VPWR VPWR sky130_fd_sc_hd__decap_3
XFILLER_0_29 VPWR VGND VPWR VGND sky130_ef_sc_hd__decap_12
XFILLER_73_199 VGND VGND VPWR VPWR sky130_fd_sc_hd__fill_1
XFILLER_14_222 VGND VGND VPWR VPWR sky130_fd_sc_hd__decap_3
XFILLER_9_27 VPWR VGND VPWR VGND sky130_ef_sc_hd__decap_12
XFILLER_14_277 VGND VGND VPWR VPWR sky130_fd_sc_hd__fill_1
Xfanout81 _1830_ VGND VGND VPWR VPWR net81 sky130_fd_sc_hd__clkbuf_4
XPHY_EDGE_ROW_54_Left_148 VGND VGND VPWR VPWR sky130_fd_sc_hd__decap_3
Xfanout92 net93 VGND VGND VPWR VPWR net92 sky130_fd_sc_hd__clkbuf_4
XFILLER_6_421 VPWR VGND VPWR VGND sky130_ef_sc_hd__decap_12
XFILLER_89_51 VGND VGND VPWR VPWR sky130_fd_sc_hd__decap_4
X_2280_ net218 net259 _1972_ VGND VGND VPWR VPWR _1979_ sky130_fd_sc_hd__a21oi_1
XPHY_EDGE_ROW_63_Left_157 VGND VGND VPWR VPWR sky130_fd_sc_hd__decap_3
XFILLER_1_181 VGND VGND VPWR VPWR sky130_fd_sc_hd__fill_2
XFILLER_77_461 VGND VGND VPWR VPWR sky130_fd_sc_hd__fill_2
XFILLER_49_185 VPWR VGND VPWR VGND sky130_ef_sc_hd__decap_12
XFILLER_92_475 VGND VGND VPWR VPWR sky130_fd_sc_hd__fill_1
XTAP_TAPCELL_ROW_63_802 VGND VPWR sky130_fd_sc_hd__tapvpwrvgnd_1
XTAP_TAPCELL_ROW_35_537 VGND VPWR sky130_fd_sc_hd__tapvpwrvgnd_1
XFILLER_33_553 VGND VGND VPWR VPWR sky130_fd_sc_hd__fill_1
XFILLER_45_391 VGND VGND VPWR VPWR sky130_fd_sc_hd__fill_1
XFILLER_60_350 VPWR VGND VPWR VGND sky130_ef_sc_hd__decap_12
XPHY_EDGE_ROW_72_Left_166 VGND VGND VPWR VPWR sky130_fd_sc_hd__decap_3
X_3803_ _1671_ _1686_ VGND VGND VPWR VPWR _1692_ sky130_fd_sc_hd__xnor2_2
X_3734_ net185 net198 net183 net196 VGND VGND VPWR VPWR _1623_ sky130_fd_sc_hd__and4_1
XFILLER_9_281 VGND VGND VPWR VPWR sky130_fd_sc_hd__fill_2
X_3665_ _1552_ _1553_ _1545_ VGND VGND VPWR VPWR _1554_ sky130_fd_sc_hd__a21oi_1
X_2616_ _0506_ _0510_ _0512_ VGND VGND VPWR VPWR _0587_ sky130_fd_sc_hd__o21a_1
X_3596_ _1453_ _1484_ VGND VGND VPWR VPWR _1485_ sky130_fd_sc_hd__nor2_1
XPHY_EDGE_ROW_81_Left_175 VGND VGND VPWR VPWR sky130_fd_sc_hd__decap_3
X_2547_ _2106_ _0530_ VGND VGND VPWR VPWR _0532_ sky130_fd_sc_hd__nor2_1
XFILLER_87_225 VGND VGND VPWR VPWR sky130_fd_sc_hd__decap_8
X_2478_ _0436_ _0450_ _0456_ _0461_ VGND VGND VPWR VPWR _0463_ sky130_fd_sc_hd__o211a_1
X_4217_ net228 VGND VGND VPWR VPWR _0198_ sky130_fd_sc_hd__inv_2
X_4148_ net234 VGND VGND VPWR VPWR _0129_ sky130_fd_sc_hd__inv_2
XFILLER_83_475 VPWR VGND VPWR VGND sky130_ef_sc_hd__decap_12
X_4079_ net225 VGND VGND VPWR VPWR _0060_ sky130_fd_sc_hd__inv_2
XPHY_EDGE_ROW_90_Left_184 VGND VGND VPWR VPWR sky130_fd_sc_hd__decap_3
XFILLER_70_158 VPWR VGND VPWR VGND sky130_ef_sc_hd__decap_12
XFILLER_24_531 VGND VGND VPWR VPWR sky130_fd_sc_hd__fill_1
XFILLER_24_553 VGND VGND VPWR VPWR sky130_fd_sc_hd__fill_1
XFILLER_51_383 VGND VGND VPWR VPWR sky130_fd_sc_hd__decap_8
XFILLER_11_236 VPWR VGND VPWR VGND sky130_ef_sc_hd__decap_12
XFILLER_11_225 VGND VGND VPWR VPWR sky130_fd_sc_hd__decap_6
Xclkload1 clknet_2_2__leaf_clk VGND VGND VPWR VPWR clkload1/X sky130_fd_sc_hd__clkbuf_4
XFILLER_50_56 VGND VGND VPWR VPWR sky130_fd_sc_hd__decap_8
XFILLER_1_3 VPWR VGND VPWR VGND sky130_ef_sc_hd__decap_12
XFILLER_59_54 VGND VGND VPWR VPWR sky130_fd_sc_hd__fill_2
XTAP_TAPCELL_ROW_6_262 VGND VPWR sky130_fd_sc_hd__tapvpwrvgnd_1
XFILLER_59_87 VPWR VGND VPWR VGND sky130_ef_sc_hd__decap_12
XFILLER_93_217 VGND VGND VPWR VPWR sky130_fd_sc_hd__decap_3
XPHY_EDGE_ROW_3_Left_97 VGND VGND VPWR VPWR sky130_fd_sc_hd__decap_3
XFILLER_59_461 VGND VGND VPWR VPWR sky130_fd_sc_hd__fill_1
Xfanout260 net22 VGND VGND VPWR VPWR net260 sky130_fd_sc_hd__buf_2
Xfanout271 net18 VGND VGND VPWR VPWR net271 sky130_fd_sc_hd__buf_2
XFILLER_34_306 VGND VGND VPWR VPWR sky130_fd_sc_hd__fill_2
XFILLER_34_339 VGND VGND VPWR VPWR sky130_fd_sc_hd__fill_1
XFILLER_15_553 VGND VGND VPWR VPWR sky130_fd_sc_hd__fill_1
XFILLER_61_169 VPWR VGND VPWR VGND sky130_ef_sc_hd__decap_12
XTAP_TAPCELL_ROW_32_507 VGND VPWR sky130_fd_sc_hd__tapvpwrvgnd_1
XFILLER_30_545 VGND VGND VPWR VPWR sky130_fd_sc_hd__decap_8
XTAP_TAPCELL_ROW_40_584 VGND VPWR sky130_fd_sc_hd__tapvpwrvgnd_1
X_3450_ _1363_ _1366_ net136 VGND VGND VPWR VPWR _0316_ sky130_fd_sc_hd__mux2_1
X_3381_ _1274_ _1286_ _1297_ VGND VGND VPWR VPWR _1302_ sky130_fd_sc_hd__o21ai_1
X_2401_ _2051_ _2076_ _2091_ VGND VGND VPWR VPWR _2100_ sky130_fd_sc_hd__a21oi_1
X_2332_ _2028_ _2030_ VGND VGND VPWR VPWR _2031_ sky130_fd_sc_hd__or2_1
X_2263_ _1960_ _1961_ VGND VGND VPWR VPWR _1962_ sky130_fd_sc_hd__and2_1
X_4002_ net396 _1849_ _1850_ VGND VGND VPWR VPWR _1853_ sky130_fd_sc_hd__o21ai_1
X_2194_ systolic_unit_0.U_11.acc_0\[3\] systolic_unit_0.U_11.acc_1\[3\] net144 VGND
+ VGND VPWR VPWR _1897_ sky130_fd_sc_hd__mux2_1
XFILLER_37_155 VPWR VGND VPWR VGND sky130_ef_sc_hd__decap_12
XTAP_TAPCELL_ROW_48_662 VGND VPWR sky130_fd_sc_hd__tapvpwrvgnd_1
XFILLER_92_294 VPWR VGND VPWR VGND sky130_ef_sc_hd__decap_12
XFILLER_80_445 VGND VGND VPWR VPWR sky130_fd_sc_hd__decap_8
XFILLER_33_361 VGND VGND VPWR VPWR sky130_fd_sc_hd__decap_6
XFILLER_40_309 VGND VGND VPWR VPWR sky130_fd_sc_hd__decap_3
X_3717_ _1605_ _1575_ VGND VGND VPWR VPWR _1606_ sky130_fd_sc_hd__and2b_1
XFILLER_20_15 VPWR VGND VPWR VGND sky130_ef_sc_hd__decap_12
XFILLER_20_59 VPWR VGND VPWR VGND sky130_ef_sc_hd__decap_12
X_3648_ net187 net191 _1502_ VGND VGND VPWR VPWR _1537_ sky130_fd_sc_hd__a21oi_1
XFILLER_88_501 VPWR VGND VPWR VGND sky130_ef_sc_hd__decap_12
X_3579_ _1457_ _1467_ VGND VGND VPWR VPWR _1468_ sky130_fd_sc_hd__or2_1
XTAP_TAPCELL_ROW_93_1093 VGND VPWR sky130_fd_sc_hd__tapvpwrvgnd_1
XTAP_TAPCELL_ROW_93_1082 VGND VPWR sky130_fd_sc_hd__tapvpwrvgnd_1
XFILLER_88_545 VGND VGND VPWR VPWR sky130_fd_sc_hd__decap_8
XFILLER_0_449 VPWR VGND VPWR VGND sky130_ef_sc_hd__decap_12
XFILLER_48_409 VGND VGND VPWR VPWR sky130_fd_sc_hd__decap_8
XFILLER_75_206 VPWR VGND VPWR VGND sky130_ef_sc_hd__decap_12
Xhold46 systolic_unit_0.U_10.acc_1\[3\] VGND VGND VPWR VPWR net321 sky130_fd_sc_hd__dlygate4sd3_1
Xhold35 systolic_unit_0.U_10.acc_1\[9\] VGND VGND VPWR VPWR net310 sky130_fd_sc_hd__dlygate4sd3_1
Xhold24 systolic_unit_0.U_10.acc_1\[13\] VGND VGND VPWR VPWR net299 sky130_fd_sc_hd__dlygate4sd3_1
XFILLER_75_239 VGND VGND VPWR VPWR sky130_fd_sc_hd__decap_3
Xhold79 net39 VGND VGND VPWR VPWR net354 sky130_fd_sc_hd__dlygate4sd3_1
XTAP_TAPCELL_ROW_3_232 VGND VPWR sky130_fd_sc_hd__tapvpwrvgnd_1
Xhold57 net44 VGND VGND VPWR VPWR net332 sky130_fd_sc_hd__dlygate4sd3_1
Xhold68 net63 VGND VGND VPWR VPWR net343 sky130_fd_sc_hd__dlygate4sd3_1
XFILLER_90_209 VPWR VGND VPWR VGND sky130_ef_sc_hd__decap_12
XTAP_TAPCELL_ROW_74_908 VGND VPWR sky130_fd_sc_hd__tapvpwrvgnd_1
XFILLER_56_453 VPWR VGND VPWR VGND sky130_ef_sc_hd__decap_12
XFILLER_16_317 VGND VGND VPWR VPWR sky130_fd_sc_hd__fill_1
XFILLER_43_103 VGND VGND VPWR VPWR sky130_fd_sc_hd__decap_8
XFILLER_43_125 VGND VGND VPWR VPWR sky130_fd_sc_hd__decap_4
XTAP_TAPCELL_ROW_82_985 VGND VPWR sky130_fd_sc_hd__tapvpwrvgnd_1
XFILLER_71_478 VPWR VGND VPWR VGND sky130_ef_sc_hd__decap_12
XFILLER_12_501 VPWR VGND VPWR VGND sky130_ef_sc_hd__decap_12
XFILLER_43_169 VGND VGND VPWR VPWR sky130_fd_sc_hd__decap_4
XFILLER_12_545 VGND VGND VPWR VPWR sky130_fd_sc_hd__decap_8
XFILLER_61_99 VGND VGND VPWR VPWR sky130_fd_sc_hd__decap_3
XFILLER_86_41 VPWR VGND VPWR VGND sky130_ef_sc_hd__decap_12
XFILLER_86_85 VPWR VGND VPWR VGND sky130_ef_sc_hd__decap_12
XFILLER_59_291 VGND VGND VPWR VPWR sky130_fd_sc_hd__fill_2
XFILLER_47_442 VGND VGND VPWR VPWR sky130_fd_sc_hd__decap_6
XTAP_TAPCELL_ROW_45_632 VGND VPWR sky130_fd_sc_hd__tapvpwrvgnd_1
X_2950_ _0883_ _0885_ VGND VGND VPWR VPWR _0903_ sky130_fd_sc_hd__xnor2_1
XTAP_TAPCELL_ROW_17_367 VGND VPWR sky130_fd_sc_hd__tapvpwrvgnd_1
XFILLER_15_361 VPWR VGND VPWR VGND sky130_ef_sc_hd__decap_12
X_2881_ _0832_ _0833_ _0831_ VGND VGND VPWR VPWR _0834_ sky130_fd_sc_hd__a21boi_1
XFILLER_15_383 VGND VGND VPWR VPWR sky130_fd_sc_hd__decap_3
X_3502_ net302 _1404_ _1406_ net416 _1402_ VGND VGND VPWR VPWR _0304_ sky130_fd_sc_hd__o221a_1
X_4482_ clknet_leaf_1_clk net299 _0206_ VGND VGND VPWR VPWR systolic_unit_0.out_acc_1_r1\[13\]
+ sky130_fd_sc_hd__dfrtp_1
X_3433_ _1029_ _1345_ VGND VGND VPWR VPWR _1353_ sky130_fd_sc_hd__xnor2_1
X_3364_ _1280_ _1284_ VGND VGND VPWR VPWR _1285_ sky130_fd_sc_hd__nand2_1
X_2315_ _2011_ _2012_ _2008_ VGND VGND VPWR VPWR _2014_ sky130_fd_sc_hd__a21bo_1
X_3295_ _1180_ _1213_ _1212_ VGND VGND VPWR VPWR _1216_ sky130_fd_sc_hd__o21bai_1
X_2246_ _1939_ _1944_ VGND VGND VPWR VPWR _1945_ sky130_fd_sc_hd__nand2b_1
XTAP_TAPCELL_ROW_0_202 VGND VPWR sky130_fd_sc_hd__tapvpwrvgnd_1
XTAP_TAPCELL_ROW_84_1004 VGND VPWR sky130_fd_sc_hd__tapvpwrvgnd_1
X_2177_ net349 _1888_ net91 VGND VGND VPWR VPWR _0397_ sky130_fd_sc_hd__mux2_1
XFILLER_25_125 VPWR VGND VPWR VGND sky130_ef_sc_hd__decap_12
XFILLER_53_445 VGND VGND VPWR VPWR sky130_fd_sc_hd__decap_3
XFILLER_80_253 VGND VGND VPWR VPWR sky130_fd_sc_hd__fill_1
XFILLER_15_26 VGND VGND VPWR VPWR sky130_fd_sc_hd__decap_8
XFILLER_15_15 VGND VGND VPWR VPWR sky130_fd_sc_hd__fill_2
XFILLER_40_139 VGND VGND VPWR VPWR sky130_fd_sc_hd__fill_1
XFILLER_31_69 VGND VGND VPWR VPWR sky130_fd_sc_hd__decap_6
Xoutput58 net58 VGND VGND VPWR VPWR D_c_flat[27] sky130_fd_sc_hd__buf_2
Xoutput47 net47 VGND VGND VPWR VPWR D_c_flat[17] sky130_fd_sc_hd__buf_2
Xoutput69 net69 VGND VGND VPWR VPWR D_c_flat[8] sky130_fd_sc_hd__buf_2
XFILLER_0_279 VGND VGND VPWR VPWR sky130_fd_sc_hd__fill_1
XFILLER_56_44 VPWR VGND VPWR VGND sky130_ef_sc_hd__decap_12
XFILLER_56_66 VGND VGND VPWR VPWR sky130_fd_sc_hd__decap_4
XFILLER_91_529 VPWR VGND VPWR VGND sky130_ef_sc_hd__decap_12
XFILLER_56_77 VGND VGND VPWR VPWR sky130_fd_sc_hd__decap_6
XFILLER_16_169 VGND VGND VPWR VPWR sky130_fd_sc_hd__decap_6
XTAP_TAPCELL_ROW_42_602 VGND VPWR sky130_fd_sc_hd__tapvpwrvgnd_1
XTAP_TAPCELL_ROW_14_337 VGND VPWR sky130_fd_sc_hd__tapvpwrvgnd_1
XFILLER_31_128 VPWR VGND VPWR VGND sky130_ef_sc_hd__decap_12
XFILLER_12_353 VGND VGND VPWR VPWR sky130_fd_sc_hd__decap_8
XFILLER_8_302 VGND VGND VPWR VPWR sky130_fd_sc_hd__decap_6
X_3080_ _0994_ _1000_ VGND VGND VPWR VPWR _1001_ sky130_fd_sc_hd__nand2_1
XFILLER_47_261 VGND VGND VPWR VPWR sky130_fd_sc_hd__fill_1
XFILLER_62_231 VGND VGND VPWR VPWR sky130_fd_sc_hd__decap_6
X_3982_ systolic_unit_0.U_11.acc_1\[3\] net74 net81 systolic_unit_0.U_01.acc_1\[3\]
+ VGND VGND VPWR VPWR _1843_ sky130_fd_sc_hd__a22o_1
X_2933_ _0883_ _0884_ _0880_ VGND VGND VPWR VPWR _0886_ sky130_fd_sc_hd__a21oi_2
XFILLER_22_139 VGND VGND VPWR VPWR sky130_fd_sc_hd__fill_1
XFILLER_62_297 VGND VGND VPWR VPWR sky130_fd_sc_hd__decap_4
X_2864_ _0814_ _0816_ VGND VGND VPWR VPWR _0817_ sky130_fd_sc_hd__and2b_1
XFILLER_30_172 VGND VGND VPWR VPWR sky130_fd_sc_hd__fill_1
X_2795_ net128 net167 _0747_ _0745_ VGND VGND VPWR VPWR _0748_ sky130_fd_sc_hd__a31o_1
XFILLER_30_183 VGND VGND VPWR VPWR sky130_fd_sc_hd__fill_1
X_4465_ clknet_leaf_6_clk _0414_ _0189_ VGND VGND VPWR VPWR net43 sky130_fd_sc_hd__dfrtp_1
X_3416_ _1199_ _1333_ _1198_ VGND VGND VPWR VPWR _1337_ sky130_fd_sc_hd__o21ai_1
X_4396_ clknet_leaf_18_clk net131 _0120_ VGND VGND VPWR VPWR systolic_unit_0.U_01.out_b\[0\]
+ sky130_fd_sc_hd__dfrtp_1
XTAP_TAPCELL_ROW_90_1052 VGND VPWR sky130_fd_sc_hd__tapvpwrvgnd_1
X_3347_ net115 systolic_unit_0.U_00.out_b\[2\] VGND VGND VPWR VPWR _1268_ sky130_fd_sc_hd__nand2_1
X_3278_ _1158_ _1196_ _1194_ _1192_ VGND VGND VPWR VPWR _1199_ sky130_fd_sc_hd__o211a_1
X_2229_ _1925_ _1927_ net262 net212 VGND VGND VPWR VPWR _1928_ sky130_fd_sc_hd__o211a_1
XFILLER_73_529 VPWR VGND VPWR VGND sky130_ef_sc_hd__decap_12
XFILLER_38_261 VGND VGND VPWR VPWR sky130_fd_sc_hd__decap_3
XTAP_TAPCELL_ROW_56_738 VGND VPWR sky130_fd_sc_hd__tapvpwrvgnd_1
XFILLER_26_434 VPWR VGND VPWR VGND sky130_ef_sc_hd__decap_12
XFILLER_13_106 VGND VGND VPWR VPWR sky130_fd_sc_hd__decap_6
XFILLER_26_489 VPWR VGND VPWR VGND sky130_ef_sc_hd__decap_12
XFILLER_13_139 VPWR VGND VPWR VGND sky130_ef_sc_hd__decap_12
XFILLER_41_426 VPWR VGND VPWR VGND sky130_ef_sc_hd__decap_12
XTAP_TAPCELL_ROW_11_307 VGND VPWR sky130_fd_sc_hd__tapvpwrvgnd_1
XFILLER_5_349 VGND VGND VPWR VPWR sky130_fd_sc_hd__decap_8
XFILLER_67_54 VGND VGND VPWR VPWR sky130_fd_sc_hd__fill_2
XFILLER_67_76 VPWR VGND VPWR VGND sky130_ef_sc_hd__decap_12
XFILLER_36_209 VPWR VGND VPWR VGND sky130_ef_sc_hd__decap_12
XTAP_TAPCELL_ROW_27_462 VGND VPWR sky130_fd_sc_hd__tapvpwrvgnd_1
XFILLER_32_459 VGND VGND VPWR VPWR sky130_fd_sc_hd__decap_4
XFILLER_66_6 VGND VGND VPWR VPWR sky130_fd_sc_hd__fill_2
X_2580_ _0554_ _0556_ VGND VGND VPWR VPWR _0564_ sky130_fd_sc_hd__xor2_2
X_4250_ net235 VGND VGND VPWR VPWR _0231_ sky130_fd_sc_hd__inv_2
XFILLER_86_109 VPWR VGND VPWR VGND sky130_ef_sc_hd__decap_12
X_3201_ _1102_ _1121_ VGND VGND VPWR VPWR _1122_ sky130_fd_sc_hd__nor2_1
X_4181_ net241 VGND VGND VPWR VPWR _0162_ sky130_fd_sc_hd__inv_2
X_3132_ _1034_ _1047_ VGND VGND VPWR VPWR _1053_ sky130_fd_sc_hd__xnor2_1
XFILLER_82_315 VGND VGND VPWR VPWR sky130_fd_sc_hd__fill_1
X_3063_ net106 net152 VGND VGND VPWR VPWR _0984_ sky130_fd_sc_hd__and2_1
XTAP_TAPCELL_ROW_53_708 VGND VPWR sky130_fd_sc_hd__tapvpwrvgnd_1
X_3965_ _1867_ _1795_ _1834_ VGND VGND VPWR VPWR _0257_ sky130_fd_sc_hd__a21o_1
X_2916_ _0866_ _0868_ _0842_ VGND VGND VPWR VPWR _0869_ sky130_fd_sc_hd__a21oi_1
X_3896_ net98 systolic_unit_0.U_01.drain_0 VGND VGND VPWR VPWR _1785_ sky130_fd_sc_hd__nand2_1
XTAP_TAPCELL_ROW_61_785 VGND VPWR sky130_fd_sc_hd__tapvpwrvgnd_1
X_2847_ _0760_ _0799_ VGND VGND VPWR VPWR _0800_ sky130_fd_sc_hd__nor2_1
XFILLER_12_27 VGND VGND VPWR VPWR sky130_fd_sc_hd__fill_1
X_2778_ _0701_ _0717_ _0730_ VGND VGND VPWR VPWR _0731_ sky130_fd_sc_hd__o21a_1
Xhold110 systolic_unit_0.U_00.acc_1\[13\] VGND VGND VPWR VPWR net385 sky130_fd_sc_hd__dlygate4sd3_1
Xhold121 matrix_count\[1\] VGND VGND VPWR VPWR net396 sky130_fd_sc_hd__dlygate4sd3_1
X_4517_ clknet_leaf_25_clk net13 _0241_ VGND VGND VPWR VPWR systolic_unit_0.U_10.in_a\[4\]
+ sky130_fd_sc_hd__dfrtp_1
Xhold132 systolic_unit_0.U_11.acc_0\[15\] VGND VGND VPWR VPWR net407 sky130_fd_sc_hd__dlygate4sd3_1
Xhold143 systolic_unit_0.U_01.acc_1\[10\] VGND VGND VPWR VPWR net418 sky130_fd_sc_hd__dlygate4sd3_1
X_4448_ clknet_leaf_5_clk net262 _0172_ VGND VGND VPWR VPWR systolic_unit_0.U_00.out_b\[4\]
+ sky130_fd_sc_hd__dfrtp_1
X_4379_ clknet_leaf_15_clk _0352_ _0103_ VGND VGND VPWR VPWR systolic_unit_0.U_01.acc_0\[15\]
+ sky130_fd_sc_hd__dfrtp_1
XFILLER_37_57 VPWR VGND VPWR VGND sky130_ef_sc_hd__decap_12
XFILLER_58_389 VGND VGND VPWR VPWR sky130_fd_sc_hd__decap_4
XFILLER_26_253 VGND VGND VPWR VPWR sky130_fd_sc_hd__fill_1
XFILLER_26_275 VGND VGND VPWR VPWR sky130_fd_sc_hd__fill_1
XFILLER_41_212 VGND VGND VPWR VPWR sky130_fd_sc_hd__decap_3
XFILLER_41_223 VGND VGND VPWR VPWR sky130_fd_sc_hd__fill_1
XTAP_TAPCELL_ROW_24_432 VGND VPWR sky130_fd_sc_hd__tapvpwrvgnd_1
XFILLER_5_113 VGND VGND VPWR VPWR sky130_fd_sc_hd__decap_6
XFILLER_89_492 VPWR VGND VPWR VGND sky130_ef_sc_hd__decap_12
XFILLER_76_197 VGND VGND VPWR VPWR sky130_fd_sc_hd__decap_8
XFILLER_64_359 VGND VGND VPWR VPWR sky130_fd_sc_hd__decap_4
XFILLER_91_167 VGND VGND VPWR VPWR sky130_fd_sc_hd__fill_1
XFILLER_60_521 VGND VGND VPWR VPWR sky130_fd_sc_hd__decap_8
XFILLER_32_234 VPWR VGND VPWR VGND sky130_ef_sc_hd__decap_12
X_3750_ _1637_ _1638_ _1629_ VGND VGND VPWR VPWR _1639_ sky130_fd_sc_hd__o21a_1
X_2701_ _0640_ _0653_ VGND VGND VPWR VPWR _0654_ sky130_fd_sc_hd__xnor2_1
XFILLER_9_441 VGND VGND VPWR VPWR sky130_fd_sc_hd__decap_6
XFILLER_9_485 VPWR VGND VPWR VGND sky130_ef_sc_hd__decap_12
X_3681_ _1560_ _1565_ _1563_ VGND VGND VPWR VPWR _1570_ sky130_fd_sc_hd__a21o_1
X_2632_ net100 _0582_ net80 systolic_unit_0.U_00.acc_1\[5\] VGND VGND VPWR VPWR _0358_
+ sky130_fd_sc_hd__a22o_1
X_2563_ _0546_ _0547_ VGND VGND VPWR VPWR _0548_ sky130_fd_sc_hd__nor2_1
X_4302_ clknet_leaf_22_clk _0283_ _0026_ VGND VGND VPWR VPWR systolic_unit_0.U_11.acc_0\[10\]
+ sky130_fd_sc_hd__dfrtp_1
X_4233_ net228 VGND VGND VPWR VPWR _0214_ sky130_fd_sc_hd__inv_2
X_2494_ _0473_ _0477_ VGND VGND VPWR VPWR _0479_ sky130_fd_sc_hd__or2_1
XFILLER_4_83 VGND VGND VPWR VPWR sky130_fd_sc_hd__fill_1
X_4164_ net234 VGND VGND VPWR VPWR _0145_ sky130_fd_sc_hd__inv_2
X_3115_ net111 net109 net154 net152 VGND VGND VPWR VPWR _1036_ sky130_fd_sc_hd__nand4_1
XFILLER_28_507 VPWR VGND VPWR VGND sky130_ef_sc_hd__decap_12
X_4095_ net244 VGND VGND VPWR VPWR _0076_ sky130_fd_sc_hd__inv_2
XTAP_TAPCELL_ROW_66_833 VGND VPWR sky130_fd_sc_hd__tapvpwrvgnd_1
X_3046_ net94 _0963_ net78 net372 VGND VGND VPWR VPWR _0330_ sky130_fd_sc_hd__a22o_1
XFILLER_23_201 VGND VGND VPWR VPWR sky130_fd_sc_hd__fill_2
XFILLER_23_223 VGND VGND VPWR VPWR sky130_fd_sc_hd__fill_1
XFILLER_51_532 VGND VGND VPWR VPWR sky130_fd_sc_hd__fill_1
XFILLER_11_429 VPWR VGND VPWR VGND sky130_ef_sc_hd__decap_12
XTAP_TAPCELL_ROW_21_402 VGND VPWR sky130_fd_sc_hd__tapvpwrvgnd_1
XFILLER_23_15 VPWR VGND VPWR VGND sky130_ef_sc_hd__decap_12
X_3948_ _1744_ _1747_ VGND VGND VPWR VPWR _1823_ sky130_fd_sc_hd__or2_1
X_3879_ _1760_ _1765_ _1767_ VGND VGND VPWR VPWR _1768_ sky130_fd_sc_hd__o21a_1
XFILLER_2_138 VGND VGND VPWR VPWR sky130_fd_sc_hd__fill_2
XFILLER_58_120 VPWR VGND VPWR VGND sky130_ef_sc_hd__decap_12
XFILLER_19_529 VPWR VGND VPWR VGND sky130_ef_sc_hd__decap_12
XFILLER_58_153 VPWR VGND VPWR VGND sky130_ef_sc_hd__decap_12
XFILLER_73_123 VPWR VGND VPWR VGND sky130_ef_sc_hd__decap_12
XFILLER_73_167 VGND VGND VPWR VPWR sky130_fd_sc_hd__fill_1
XFILLER_64_66 VGND VGND VPWR VPWR sky130_fd_sc_hd__fill_2
XFILLER_9_39 VPWR VGND VPWR VGND sky130_ef_sc_hd__decap_12
Xfanout82 _1787_ VGND VGND VPWR VPWR net82 sky130_fd_sc_hd__clkbuf_4
Xfanout93 systolic_unit_0.drain_valid VGND VGND VPWR VPWR net93 sky130_fd_sc_hd__buf_2
XFILLER_13_81 VPWR VGND VPWR VGND sky130_ef_sc_hd__decap_12
XFILLER_6_433 VPWR VGND VPWR VGND sky130_ef_sc_hd__decap_12
XFILLER_6_477 VPWR VGND VPWR VGND sky130_ef_sc_hd__decap_12
XFILLER_1_193 VGND VGND VPWR VPWR sky130_fd_sc_hd__decap_8
XFILLER_77_484 VPWR VGND VPWR VGND sky130_ef_sc_hd__decap_12
XFILLER_92_421 VPWR VGND VPWR VGND sky130_ef_sc_hd__decap_12
XFILLER_37_337 VPWR VGND VPWR VGND sky130_ef_sc_hd__decap_12
XFILLER_49_197 VGND VGND VPWR VPWR sky130_fd_sc_hd__decap_6
XFILLER_52_307 VGND VGND VPWR VPWR sky130_fd_sc_hd__fill_1
XTAP_TAPCELL_ROW_63_803 VGND VPWR sky130_fd_sc_hd__tapvpwrvgnd_1
XTAP_TAPCELL_ROW_35_538 VGND VPWR sky130_fd_sc_hd__tapvpwrvgnd_1
X_3802_ _1689_ _1690_ VGND VGND VPWR VPWR _1691_ sky130_fd_sc_hd__or2_1
XFILLER_60_362 VGND VGND VPWR VPWR sky130_fd_sc_hd__fill_2
XTAP_TAPCELL_ROW_71_880 VGND VPWR sky130_fd_sc_hd__tapvpwrvgnd_1
X_3733_ net200 net182 VGND VGND VPWR VPWR _1622_ sky130_fd_sc_hd__nand2_1
X_3664_ _1538_ _1544_ VGND VGND VPWR VPWR _1553_ sky130_fd_sc_hd__xor2_1
Xclkload30 clknet_leaf_22_clk VGND VGND VPWR VPWR clkload30/Y sky130_fd_sc_hd__inv_6
X_2615_ net409 net89 _0586_ net210 VGND VGND VPWR VPWR _0371_ sky130_fd_sc_hd__a22o_1
X_3595_ net197 net178 _1451_ _1452_ VGND VGND VPWR VPWR _1484_ sky130_fd_sc_hd__o2bb2a_1
X_2546_ _2107_ _0528_ _0530_ VGND VGND VPWR VPWR _0531_ sky130_fd_sc_hd__a21oi_1
X_2477_ _0456_ _0461_ _0436_ _0450_ VGND VGND VPWR VPWR _0462_ sky130_fd_sc_hd__a211oi_1
XFILLER_68_440 VGND VGND VPWR VPWR sky130_fd_sc_hd__decap_4
X_4216_ net231 VGND VGND VPWR VPWR _0197_ sky130_fd_sc_hd__inv_2
XFILLER_18_15 VPWR VGND VPWR VGND sky130_ef_sc_hd__decap_12
X_4147_ net229 VGND VGND VPWR VPWR _0128_ sky130_fd_sc_hd__inv_2
XTAP_TAPCELL_ROW_87_1024 VGND VPWR sky130_fd_sc_hd__tapvpwrvgnd_1
X_4078_ net223 VGND VGND VPWR VPWR _0059_ sky130_fd_sc_hd__inv_2
XFILLER_55_167 VGND VGND VPWR VPWR sky130_fd_sc_hd__fill_1
XFILLER_83_487 VPWR VGND VPWR VGND sky130_ef_sc_hd__decap_12
X_3029_ _0908_ _0917_ VGND VGND VPWR VPWR _0970_ sky130_fd_sc_hd__nand2_1
XFILLER_51_362 VGND VGND VPWR VPWR sky130_fd_sc_hd__fill_1
XFILLER_11_248 VPWR VGND VPWR VGND sky130_ef_sc_hd__decap_12
Xclkload2 clknet_2_3__leaf_clk VGND VGND VPWR VPWR clkload2/X sky130_fd_sc_hd__clkbuf_4
XFILLER_3_447 VGND VGND VPWR VPWR sky130_fd_sc_hd__fill_1
Xfanout250 net251 VGND VGND VPWR VPWR net250 sky130_fd_sc_hd__buf_4
XFILLER_59_99 VPWR VGND VPWR VGND sky130_ef_sc_hd__decap_12
Xfanout261 net22 VGND VGND VPWR VPWR net261 sky130_fd_sc_hd__clkbuf_2
XTAP_TAPCELL_ROW_6_263 VGND VPWR sky130_fd_sc_hd__tapvpwrvgnd_1
Xfanout272 net273 VGND VGND VPWR VPWR net272 sky130_fd_sc_hd__buf_2
XFILLER_75_32 VPWR VGND VPWR VGND sky130_ef_sc_hd__decap_12
XFILLER_19_337 VGND VGND VPWR VPWR sky130_fd_sc_hd__decap_4
XFILLER_75_98 VGND VGND VPWR VPWR sky130_fd_sc_hd__fill_2
XFILLER_74_443 VGND VGND VPWR VPWR sky130_fd_sc_hd__fill_1
XFILLER_27_381 VGND VGND VPWR VPWR sky130_fd_sc_hd__decap_4
XTAP_TAPCELL_ROW_32_508 VGND VPWR sky130_fd_sc_hd__tapvpwrvgnd_1
XFILLER_42_362 VGND VGND VPWR VPWR sky130_fd_sc_hd__fill_2
XTAP_TAPCELL_ROW_40_585 VGND VPWR sky130_fd_sc_hd__tapvpwrvgnd_1
X_2400_ _2094_ _2098_ VGND VGND VPWR VPWR _2099_ sky130_fd_sc_hd__xor2_1
X_3380_ _1280_ _1284_ _1298_ VGND VGND VPWR VPWR _1301_ sky130_fd_sc_hd__a21o_1
X_2331_ _2000_ _2015_ _2027_ VGND VGND VPWR VPWR _2030_ sky130_fd_sc_hd__and3_1
X_2262_ _1937_ _1958_ _1959_ VGND VGND VPWR VPWR _1961_ sky130_fd_sc_hd__o21ai_1
XFILLER_69_237 VGND VGND VPWR VPWR sky130_fd_sc_hd__fill_1
X_4001_ matrix_count\[1\] _1849_ VGND VGND VPWR VPWR _1852_ sky130_fd_sc_hd__and2_1
XFILLER_84_229 VGND VGND VPWR VPWR sky130_fd_sc_hd__decap_3
XFILLER_77_281 VGND VGND VPWR VPWR sky130_fd_sc_hd__decap_8
X_2193_ net335 _1896_ net91 VGND VGND VPWR VPWR _0389_ sky130_fd_sc_hd__mux2_1
XFILLER_92_251 VGND VGND VPWR VPWR sky130_fd_sc_hd__fill_1
XFILLER_1_51 VGND VGND VPWR VPWR sky130_fd_sc_hd__decap_4
XFILLER_37_167 VGND VGND VPWR VPWR sky130_fd_sc_hd__fill_1
XFILLER_37_189 VGND VGND VPWR VPWR sky130_fd_sc_hd__decap_8
XFILLER_21_502 VGND VGND VPWR VPWR sky130_fd_sc_hd__fill_2
XFILLER_33_373 VGND VGND VPWR VPWR sky130_fd_sc_hd__decap_4
X_3716_ _1603_ _1604_ _1592_ VGND VGND VPWR VPWR _1605_ sky130_fd_sc_hd__o21a_1
XFILLER_20_27 VGND VGND VPWR VPWR sky130_fd_sc_hd__fill_1
X_3647_ _1510_ _1511_ VGND VGND VPWR VPWR _1536_ sky130_fd_sc_hd__xnor2_1
X_3578_ _1449_ _1456_ VGND VGND VPWR VPWR _1467_ sky130_fd_sc_hd__and2_1
XTAP_TAPCELL_ROW_93_1094 VGND VPWR sky130_fd_sc_hd__tapvpwrvgnd_1
XTAP_TAPCELL_ROW_93_1083 VGND VPWR sky130_fd_sc_hd__tapvpwrvgnd_1
XFILLER_88_513 VPWR VGND VPWR VGND sky130_ef_sc_hd__decap_12
X_2529_ _0503_ _0513_ VGND VGND VPWR VPWR _0514_ sky130_fd_sc_hd__and2_1
XFILLER_75_218 VGND VGND VPWR VPWR sky130_fd_sc_hd__decap_6
XFILLER_29_47 VGND VGND VPWR VPWR sky130_fd_sc_hd__fill_2
Xhold36 systolic_unit_0.U_10.acc_0\[11\] VGND VGND VPWR VPWR net311 sky130_fd_sc_hd__dlygate4sd3_1
Xhold25 systolic_unit_0.U_10.acc_1\[14\] VGND VGND VPWR VPWR net300 sky130_fd_sc_hd__dlygate4sd3_1
Xhold47 switch VGND VGND VPWR VPWR net322 sky130_fd_sc_hd__dlygate4sd3_1
XTAP_TAPCELL_ROW_3_233 VGND VPWR sky130_fd_sc_hd__tapvpwrvgnd_1
Xhold58 net70 VGND VGND VPWR VPWR net333 sky130_fd_sc_hd__dlygate4sd3_1
Xhold69 net40 VGND VGND VPWR VPWR net344 sky130_fd_sc_hd__dlygate4sd3_1
XFILLER_56_421 VGND VGND VPWR VPWR sky130_fd_sc_hd__fill_1
XFILLER_56_432 VPWR VGND VPWR VGND sky130_ef_sc_hd__decap_12
XTAP_TAPCELL_ROW_74_909 VGND VPWR sky130_fd_sc_hd__tapvpwrvgnd_1
XFILLER_56_465 VGND VGND VPWR VPWR sky130_fd_sc_hd__decap_8
XFILLER_71_413 VGND VGND VPWR VPWR sky130_fd_sc_hd__decap_3
XFILLER_71_435 VPWR VGND VPWR VGND sky130_ef_sc_hd__decap_12
XFILLER_45_57 VGND VGND VPWR VPWR sky130_fd_sc_hd__decap_4
XFILLER_12_513 VPWR VGND VPWR VGND sky130_ef_sc_hd__decap_12
XFILLER_61_67 VPWR VGND VPWR VGND sky130_ef_sc_hd__decap_12
XFILLER_6_29 VPWR VGND VPWR VGND sky130_ef_sc_hd__decap_12
XFILLER_10_82 VGND VGND VPWR VPWR sky130_fd_sc_hd__fill_2
XFILLER_86_53 VPWR VGND VPWR VGND sky130_ef_sc_hd__decap_12
XFILLER_86_97 VPWR VGND VPWR VGND sky130_ef_sc_hd__decap_12
XFILLER_19_145 VPWR VGND VPWR VGND sky130_ef_sc_hd__decap_12
XFILLER_19_167 VGND VGND VPWR VPWR sky130_fd_sc_hd__fill_1
XTAP_TAPCELL_ROW_45_633 VGND VPWR sky130_fd_sc_hd__tapvpwrvgnd_1
XFILLER_62_446 VPWR VGND VPWR VGND sky130_ef_sc_hd__decap_12
X_2880_ _0824_ _0830_ VGND VGND VPWR VPWR _0833_ sky130_fd_sc_hd__xor2_1
XFILLER_15_373 VGND VGND VPWR VPWR sky130_fd_sc_hd__decap_6
XFILLER_30_321 VGND VGND VPWR VPWR sky130_fd_sc_hd__decap_8
XFILLER_30_365 VGND VGND VPWR VPWR sky130_fd_sc_hd__decap_6
XFILLER_30_376 VPWR VGND VPWR VGND sky130_ef_sc_hd__decap_12
X_3501_ drain_odd net134 VGND VGND VPWR VPWR _1406_ sky130_fd_sc_hd__nand2_1
X_4481_ clknet_leaf_1_clk net305 _0205_ VGND VGND VPWR VPWR systolic_unit_0.out_acc_1_r1\[12\]
+ sky130_fd_sc_hd__dfrtp_1
X_3432_ _0977_ _1352_ net134 VGND VGND VPWR VPWR _0320_ sky130_fd_sc_hd__mux2_1
X_3363_ _1276_ _1278_ _1277_ VGND VGND VPWR VPWR _1284_ sky130_fd_sc_hd__a21o_1
XFILLER_85_505 VPWR VGND VPWR VGND sky130_ef_sc_hd__decap_12
X_2314_ _2008_ _2011_ _2012_ VGND VGND VPWR VPWR _2013_ sky130_fd_sc_hd__nand3_1
X_3294_ _1180_ _1212_ _1214_ VGND VGND VPWR VPWR _1215_ sky130_fd_sc_hd__nand3b_2
X_2245_ _1942_ _1943_ VGND VGND VPWR VPWR _1944_ sky130_fd_sc_hd__and2_1
XFILLER_38_421 VGND VGND VPWR VPWR sky130_fd_sc_hd__decap_8
XTAP_TAPCELL_ROW_0_203 VGND VPWR sky130_fd_sc_hd__tapvpwrvgnd_1
XFILLER_38_454 VGND VGND VPWR VPWR sky130_fd_sc_hd__fill_1
X_2176_ systolic_unit_0.U_11.acc_0\[12\] systolic_unit_0.U_11.acc_1\[12\] net149 VGND
+ VGND VPWR VPWR _1888_ sky130_fd_sc_hd__mux2_1
XFILLER_65_262 VPWR VGND VPWR VGND sky130_ef_sc_hd__decap_12
XFILLER_80_221 VPWR VGND VPWR VGND sky130_ef_sc_hd__decap_12
XFILLER_25_137 VPWR VGND VPWR VGND sky130_ef_sc_hd__decap_12
XFILLER_21_321 VPWR VGND VPWR VGND sky130_ef_sc_hd__decap_12
XPHY_EDGE_ROW_1_Right_1 VGND VGND VPWR VPWR sky130_fd_sc_hd__decap_3
Xoutput48 net48 VGND VGND VPWR VPWR D_c_flat[18] sky130_fd_sc_hd__buf_2
XFILLER_0_225 VPWR VGND VPWR VGND sky130_ef_sc_hd__decap_12
Xoutput59 net59 VGND VGND VPWR VPWR D_c_flat[28] sky130_fd_sc_hd__buf_2
XFILLER_88_365 VGND VGND VPWR VPWR sky130_fd_sc_hd__decap_6
XFILLER_88_354 VGND VGND VPWR VPWR sky130_fd_sc_hd__decap_8
XFILLER_56_56 VGND VGND VPWR VPWR sky130_fd_sc_hd__decap_3
XTAP_TAPCELL_ROW_59_758 VGND VPWR sky130_fd_sc_hd__tapvpwrvgnd_1
XFILLER_56_251 VGND VGND VPWR VPWR sky130_fd_sc_hd__fill_1
XFILLER_71_221 VGND VGND VPWR VPWR sky130_fd_sc_hd__decap_3
XFILLER_16_126 VGND VGND VPWR VPWR sky130_fd_sc_hd__fill_2
XTAP_TAPCELL_ROW_42_603 VGND VPWR sky130_fd_sc_hd__tapvpwrvgnd_1
XTAP_TAPCELL_ROW_14_338 VGND VPWR sky130_fd_sc_hd__tapvpwrvgnd_1
XFILLER_12_365 VPWR VGND VPWR VGND sky130_ef_sc_hd__decap_12
XTAP_TAPCELL_ROW_50_680 VGND VPWR sky130_fd_sc_hd__tapvpwrvgnd_1
XFILLER_4_531 VGND VGND VPWR VPWR sky130_fd_sc_hd__fill_1
XFILLER_4_553 VGND VGND VPWR VPWR sky130_fd_sc_hd__fill_1
XFILLER_67_505 VPWR VGND VPWR VGND sky130_ef_sc_hd__decap_12
XFILLER_35_457 VGND VGND VPWR VPWR sky130_fd_sc_hd__fill_2
X_3981_ net97 _1816_ _1842_ VGND VGND VPWR VPWR _0249_ sky130_fd_sc_hd__a21o_1
X_2932_ _0880_ _0884_ VGND VGND VPWR VPWR _0885_ sky130_fd_sc_hd__nand2b_1
X_2863_ net126 net171 net124 net173 VGND VGND VPWR VPWR _0816_ sky130_fd_sc_hd__a22o_1
X_2794_ _0743_ _0744_ VGND VGND VPWR VPWR _0747_ sky130_fd_sc_hd__xnor2_1
XFILLER_7_380 VPWR VGND VPWR VGND sky130_ef_sc_hd__decap_12
X_4464_ clknet_leaf_0_clk _0413_ _0188_ VGND VGND VPWR VPWR net42 sky130_fd_sc_hd__dfrtp_1
X_3415_ _1201_ _1335_ VGND VGND VPWR VPWR _1336_ sky130_fd_sc_hd__nor2_1
X_4395_ clknet_leaf_3_clk _0368_ _0119_ VGND VGND VPWR VPWR systolic_unit_0.U_00.acc_1\[15\]
+ sky130_fd_sc_hd__dfrtp_1
XTAP_TAPCELL_ROW_90_1053 VGND VPWR sky130_fd_sc_hd__tapvpwrvgnd_1
X_3346_ _1264_ _1265_ _1263_ VGND VGND VPWR VPWR _1267_ sky130_fd_sc_hd__a21bo_1
X_3277_ _1192_ _1194_ _1196_ _1158_ VGND VGND VPWR VPWR _1198_ sky130_fd_sc_hd__a211o_1
X_2228_ net217 net258 VGND VGND VPWR VPWR _1927_ sky130_fd_sc_hd__and2_1
XFILLER_81_541 VPWR VGND VPWR VGND sky130_ef_sc_hd__decap_12
X_2159_ net347 _1879_ net90 VGND VGND VPWR VPWR _0406_ sky130_fd_sc_hd__mux2_1
XFILLER_26_446 VPWR VGND VPWR VGND sky130_ef_sc_hd__decap_12
XFILLER_26_59 VGND VGND VPWR VPWR sky130_fd_sc_hd__fill_2
XFILLER_41_438 VGND VGND VPWR VPWR sky130_fd_sc_hd__decap_8
XFILLER_41_449 VGND VGND VPWR VPWR sky130_fd_sc_hd__decap_4
XTAP_TAPCELL_ROW_11_308 VGND VPWR sky130_fd_sc_hd__tapvpwrvgnd_1
XFILLER_49_505 VPWR VGND VPWR VGND sky130_ef_sc_hd__decap_12
XFILLER_88_195 VGND VGND VPWR VPWR sky130_fd_sc_hd__fill_1
XFILLER_67_88 VGND VGND VPWR VPWR sky130_fd_sc_hd__decap_6
XFILLER_91_305 VGND VGND VPWR VPWR sky130_fd_sc_hd__decap_3
XFILLER_44_210 VGND VGND VPWR VPWR sky130_fd_sc_hd__decap_6
XFILLER_16_92 VPWR VGND VPWR VGND sky130_ef_sc_hd__decap_12
Xclkbuf_leaf_24_clk clknet_2_1__leaf_clk VGND VGND VPWR VPWR clknet_leaf_24_clk sky130_fd_sc_hd__clkbuf_8
XFILLER_8_177 VGND VGND VPWR VPWR sky130_fd_sc_hd__fill_1
XFILLER_59_6 VPWR VGND VPWR VGND sky130_ef_sc_hd__decap_12
XFILLER_4_383 VPWR VGND VPWR VGND sky130_ef_sc_hd__decap_12
XFILLER_79_151 VPWR VGND VPWR VGND sky130_ef_sc_hd__decap_12
X_3200_ _1116_ _1120_ VGND VGND VPWR VPWR _1121_ sky130_fd_sc_hd__nor2_1
X_4180_ net250 VGND VGND VPWR VPWR _0161_ sky130_fd_sc_hd__inv_2
X_3131_ _1050_ _1051_ VGND VGND VPWR VPWR _1052_ sky130_fd_sc_hd__nand2_1
X_3062_ net106 net153 _0978_ VGND VGND VPWR VPWR _0983_ sky130_fd_sc_hd__and3_1
XTAP_TAPCELL_ROW_53_709 VGND VPWR sky130_fd_sc_hd__tapvpwrvgnd_1
XFILLER_23_449 VPWR VGND VPWR VGND sky130_ef_sc_hd__decap_12
X_3964_ systolic_unit_0.U_11.acc_1\[12\] _1827_ net81 systolic_unit_0.U_01.acc_1\[12\]
+ VGND VGND VPWR VPWR _1834_ sky130_fd_sc_hd__a22o_1
Xclkbuf_leaf_15_clk clknet_2_3__leaf_clk VGND VGND VPWR VPWR clknet_leaf_15_clk sky130_fd_sc_hd__clkbuf_8
X_2915_ _0862_ _0867_ VGND VGND VPWR VPWR _0868_ sky130_fd_sc_hd__nand2_1
X_3895_ net97 systolic_unit_0.U_01.drain_0 VGND VGND VPWR VPWR _1784_ sky130_fd_sc_hd__and2_1
X_2846_ systolic_unit_0.U_00.out_a\[0\] net118 _0758_ _0759_ VGND VGND VPWR VPWR _0799_
+ sky130_fd_sc_hd__o2bb2a_1
XFILLER_31_493 VGND VGND VPWR VPWR sky130_fd_sc_hd__decap_3
X_2777_ _0728_ _0729_ VGND VGND VPWR VPWR _0730_ sky130_fd_sc_hd__or2_1
Xhold100 systolic_unit_0.U_00.acc_0\[11\] VGND VGND VPWR VPWR net375 sky130_fd_sc_hd__dlygate4sd3_1
X_4516_ clknet_leaf_25_clk net12 _0240_ VGND VGND VPWR VPWR systolic_unit_0.U_10.in_a\[3\]
+ sky130_fd_sc_hd__dfrtp_1
Xhold133 systolic_unit_0.U_00.acc_0\[9\] VGND VGND VPWR VPWR net408 sky130_fd_sc_hd__dlygate4sd3_1
Xhold144 systolic_unit_0.U_11.acc_1\[0\] VGND VGND VPWR VPWR net419 sky130_fd_sc_hd__dlygate4sd3_1
Xhold122 systolic_unit_0.U_11.acc_0\[0\] VGND VGND VPWR VPWR net397 sky130_fd_sc_hd__dlygate4sd3_1
Xhold111 systolic_unit_0.U_01.acc_1\[0\] VGND VGND VPWR VPWR net386 sky130_fd_sc_hd__dlygate4sd3_1
Xhold155 systolic_unit_0.U_10.acc_0\[4\] VGND VGND VPWR VPWR net430 sky130_fd_sc_hd__dlygate4sd3_1
X_4447_ clknet_leaf_5_clk net265 _0171_ VGND VGND VPWR VPWR systolic_unit_0.U_00.out_b\[3\]
+ sky130_fd_sc_hd__dfrtp_1
X_4378_ clknet_leaf_16_clk _0351_ _0102_ VGND VGND VPWR VPWR systolic_unit_0.U_01.acc_0\[14\]
+ sky130_fd_sc_hd__dfrtp_1
XTAP_TAPCELL_ROW_69_853 VGND VPWR sky130_fd_sc_hd__tapvpwrvgnd_1
X_3329_ _1176_ _1189_ _1188_ VGND VGND VPWR VPWR _1250_ sky130_fd_sc_hd__a21o_1
XFILLER_37_69 VPWR VGND VPWR VGND sky130_ef_sc_hd__decap_12
XFILLER_81_393 VPWR VGND VPWR VGND sky130_ef_sc_hd__decap_12
XTAP_TAPCELL_ROW_24_433 VGND VPWR sky130_fd_sc_hd__tapvpwrvgnd_1
XFILLER_41_257 VGND VGND VPWR VPWR sky130_fd_sc_hd__decap_4
XFILLER_53_46 VGND VGND VPWR VPWR sky130_fd_sc_hd__decap_8
XFILLER_53_57 VPWR VGND VPWR VGND sky130_ef_sc_hd__decap_12
XFILLER_1_353 VGND VGND VPWR VPWR sky130_fd_sc_hd__fill_1
XFILLER_1_375 VGND VGND VPWR VPWR sky130_fd_sc_hd__fill_2
XFILLER_76_176 VPWR VGND VPWR VGND sky130_ef_sc_hd__decap_12
XFILLER_91_113 VPWR VGND VPWR VGND sky130_ef_sc_hd__decap_12
XFILLER_57_390 VGND VGND VPWR VPWR sky130_fd_sc_hd__fill_2
XFILLER_32_213 VGND VGND VPWR VPWR sky130_fd_sc_hd__fill_1
XFILLER_32_246 VGND VGND VPWR VPWR sky130_fd_sc_hd__decap_6
X_2700_ _0623_ _0652_ VGND VGND VPWR VPWR _0653_ sky130_fd_sc_hd__nor2_1
X_3680_ _1568_ _1535_ VGND VGND VPWR VPWR _1569_ sky130_fd_sc_hd__and2b_1
XFILLER_9_497 VGND VGND VPWR VPWR sky130_fd_sc_hd__decap_6
X_2631_ net99 _0581_ net79 net395 VGND VGND VPWR VPWR _0359_ sky130_fd_sc_hd__a22o_1
X_2562_ _0539_ _0541_ _0544_ VGND VGND VPWR VPWR _0547_ sky130_fd_sc_hd__and3_1
X_4301_ clknet_leaf_17_clk _0282_ _0025_ VGND VGND VPWR VPWR systolic_unit_0.U_11.acc_0\[9\]
+ sky130_fd_sc_hd__dfrtp_1
X_4232_ net231 VGND VGND VPWR VPWR _0213_ sky130_fd_sc_hd__inv_2
X_2493_ _0473_ _0477_ VGND VGND VPWR VPWR _0478_ sky130_fd_sc_hd__nand2_1
Xclkbuf_leaf_4_clk clknet_2_1__leaf_clk VGND VGND VPWR VPWR clknet_leaf_4_clk sky130_fd_sc_hd__clkbuf_8
X_4163_ net234 VGND VGND VPWR VPWR _0144_ sky130_fd_sc_hd__inv_2
X_3114_ net155 net105 _1014_ _1015_ VGND VGND VPWR VPWR _1035_ sky130_fd_sc_hd__o2bb2a_1
XFILLER_28_519 VPWR VGND VPWR VGND sky130_ef_sc_hd__decap_12
X_4094_ net244 VGND VGND VPWR VPWR _0075_ sky130_fd_sc_hd__inv_2
X_3045_ net94 _0961_ net78 net418 VGND VGND VPWR VPWR _0331_ sky130_fd_sc_hd__a22o_1
XTAP_TAPCELL_ROW_38_558 VGND VPWR sky130_fd_sc_hd__tapvpwrvgnd_1
XFILLER_70_319 VPWR VGND VPWR VGND sky130_ef_sc_hd__decap_12
XFILLER_63_393 VGND VGND VPWR VPWR sky130_fd_sc_hd__decap_8
XTAP_TAPCELL_ROW_21_403 VGND VPWR sky130_fd_sc_hd__tapvpwrvgnd_1
XFILLER_23_27 VGND VGND VPWR VPWR sky130_fd_sc_hd__fill_1
XFILLER_23_279 VGND VGND VPWR VPWR sky130_fd_sc_hd__fill_1
X_3947_ net144 _1821_ _1822_ VGND VGND VPWR VPWR _0275_ sky130_fd_sc_hd__a21o_1
XFILLER_31_290 VPWR VGND VPWR VGND sky130_ef_sc_hd__decap_12
X_3878_ _1643_ _1644_ _1766_ VGND VGND VPWR VPWR _1767_ sky130_fd_sc_hd__a21o_1
X_2829_ net130 net168 VGND VGND VPWR VPWR _0782_ sky130_fd_sc_hd__nand2_1
XFILLER_78_419 VGND VGND VPWR VPWR sky130_fd_sc_hd__fill_1
XFILLER_48_35 VPWR VGND VPWR VGND sky130_ef_sc_hd__decap_12
XFILLER_58_110 VGND VGND VPWR VPWR sky130_fd_sc_hd__decap_3
XFILLER_58_132 VGND VGND VPWR VPWR sky130_fd_sc_hd__decap_8
XFILLER_58_165 VGND VGND VPWR VPWR sky130_fd_sc_hd__decap_4
XFILLER_73_135 VGND VGND VPWR VPWR sky130_fd_sc_hd__fill_1
XFILLER_73_113 VGND VGND VPWR VPWR sky130_fd_sc_hd__decap_3
XFILLER_73_157 VGND VGND VPWR VPWR sky130_fd_sc_hd__fill_1
XFILLER_27_530 VPWR VGND VPWR VGND sky130_ef_sc_hd__decap_12
XFILLER_14_246 VGND VGND VPWR VPWR sky130_fd_sc_hd__decap_6
XFILLER_64_89 VGND VGND VPWR VPWR sky130_fd_sc_hd__fill_1
Xfanout83 _1405_ VGND VGND VPWR VPWR net83 sky130_fd_sc_hd__clkbuf_4
Xfanout94 net95 VGND VGND VPWR VPWR net94 sky130_fd_sc_hd__buf_2
XFILLER_6_401 VPWR VGND VPWR VGND sky130_ef_sc_hd__decap_12
XFILLER_13_93 VGND VGND VPWR VPWR sky130_fd_sc_hd__decap_8
XFILLER_6_445 VPWR VGND VPWR VGND sky130_ef_sc_hd__decap_12
XFILLER_6_489 VPWR VGND VPWR VGND sky130_ef_sc_hd__decap_12
XFILLER_69_408 VGND VGND VPWR VPWR sky130_fd_sc_hd__decap_8
XTAP_TAPCELL_ROW_9_283 VGND VPWR sky130_fd_sc_hd__tapvpwrvgnd_1
XFILLER_92_433 VPWR VGND VPWR VGND sky130_ef_sc_hd__decap_12
XFILLER_77_496 VGND VGND VPWR VPWR sky130_fd_sc_hd__decap_8
XFILLER_37_349 VPWR VGND VPWR VGND sky130_ef_sc_hd__decap_12
XFILLER_92_477 VPWR VGND VPWR VGND sky130_ef_sc_hd__decap_12
XFILLER_18_530 VGND VGND VPWR VPWR sky130_fd_sc_hd__fill_2
XTAP_TAPCELL_ROW_63_804 VGND VPWR sky130_fd_sc_hd__tapvpwrvgnd_1
X_3801_ _1630_ _1688_ VGND VGND VPWR VPWR _1690_ sky130_fd_sc_hd__nor2_1
XFILLER_13_290 VGND VGND VPWR VPWR sky130_fd_sc_hd__decap_8
X_3732_ _1614_ _1620_ VGND VGND VPWR VPWR _1621_ sky130_fd_sc_hd__nand2_1
X_3663_ _1550_ _1551_ VGND VGND VPWR VPWR _1552_ sky130_fd_sc_hd__nor2_1
Xclkload20 clknet_leaf_10_clk VGND VGND VPWR VPWR clkload20/Y sky130_fd_sc_hd__inv_6
X_2614_ _0507_ _0514_ _0585_ VGND VGND VPWR VPWR _0586_ sky130_fd_sc_hd__nor3_1
X_3594_ net199 net178 _1481_ _1479_ VGND VGND VPWR VPWR _1483_ sky130_fd_sc_hd__a31o_1
X_2545_ _2102_ _2105_ _2071_ _2074_ VGND VGND VPWR VPWR _0530_ sky130_fd_sc_hd__a211oi_1
XFILLER_87_216 VGND VGND VPWR VPWR sky130_fd_sc_hd__decap_8
XFILLER_87_205 VGND VGND VPWR VPWR sky130_fd_sc_hd__decap_6
X_2476_ _0456_ _0458_ _0459_ _0460_ VGND VGND VPWR VPWR _0461_ sky130_fd_sc_hd__nand4_2
X_4215_ net237 VGND VGND VPWR VPWR _0196_ sky130_fd_sc_hd__inv_2
XFILLER_83_400 VPWR VGND VPWR VGND sky130_ef_sc_hd__decap_12
XFILLER_68_452 VPWR VGND VPWR VGND sky130_ef_sc_hd__decap_12
XFILLER_28_305 VGND VGND VPWR VPWR sky130_fd_sc_hd__decap_3
X_4146_ net245 VGND VGND VPWR VPWR _0127_ sky130_fd_sc_hd__inv_2
XTAP_TAPCELL_ROW_87_1025 VGND VPWR sky130_fd_sc_hd__tapvpwrvgnd_1
XFILLER_18_27 VGND VGND VPWR VPWR sky130_fd_sc_hd__fill_1
XFILLER_55_113 VPWR VGND VPWR VGND sky130_ef_sc_hd__decap_12
XFILLER_83_455 VGND VGND VPWR VPWR sky130_fd_sc_hd__fill_1
X_4077_ net225 VGND VGND VPWR VPWR _0058_ sky130_fd_sc_hd__inv_2
XFILLER_83_499 VGND VGND VPWR VPWR sky130_fd_sc_hd__decap_4
X_3028_ systolic_unit_0.U_01.acc_0\[4\] net84 _0969_ net138 VGND VGND VPWR VPWR _0341_
+ sky130_fd_sc_hd__a22o_1
XFILLER_24_511 VPWR VGND VPWR VGND sky130_ef_sc_hd__decap_12
XFILLER_70_138 VGND VGND VPWR VPWR sky130_fd_sc_hd__fill_2
XFILLER_24_533 VPWR VGND VPWR VGND sky130_ef_sc_hd__decap_12
XFILLER_11_205 VPWR VGND VPWR VGND sky130_ef_sc_hd__decap_12
XFILLER_7_209 VGND VGND VPWR VPWR sky130_fd_sc_hd__decap_4
Xclkload3 clknet_leaf_0_clk VGND VGND VPWR VPWR clkload3/Y sky130_fd_sc_hd__clkinvlp_4
XFILLER_78_249 VGND VGND VPWR VPWR sky130_fd_sc_hd__decap_3
Xfanout240 net242 VGND VGND VPWR VPWR net240 sky130_fd_sc_hd__buf_4
XTAP_TAPCELL_ROW_77_929 VGND VPWR sky130_fd_sc_hd__tapvpwrvgnd_1
Xfanout262 net263 VGND VGND VPWR VPWR net262 sky130_fd_sc_hd__buf_4
Xfanout273 net17 VGND VGND VPWR VPWR net273 sky130_fd_sc_hd__buf_2
Xfanout251 net252 VGND VGND VPWR VPWR net251 sky130_fd_sc_hd__buf_4
XFILLER_86_271 VPWR VGND VPWR VGND sky130_ef_sc_hd__decap_12
XFILLER_75_44 VPWR VGND VPWR VGND sky130_ef_sc_hd__decap_12
XFILLER_74_477 VPWR VGND VPWR VGND sky130_ef_sc_hd__decap_12
XFILLER_34_319 VPWR VGND VPWR VGND sky130_ef_sc_hd__decap_12
XFILLER_27_393 VPWR VGND VPWR VGND sky130_ef_sc_hd__decap_12
XTAP_TAPCELL_ROW_32_509 VGND VPWR sky130_fd_sc_hd__tapvpwrvgnd_1
XFILLER_30_514 VPWR VGND VPWR VGND sky130_ef_sc_hd__decap_12
XFILLER_24_81 VGND VGND VPWR VPWR sky130_fd_sc_hd__decap_3
XTAP_TAPCELL_ROW_40_586 VGND VPWR sky130_fd_sc_hd__tapvpwrvgnd_1
XFILLER_6_242 VGND VGND VPWR VPWR sky130_fd_sc_hd__fill_1
XFILLER_6_264 VGND VGND VPWR VPWR sky130_fd_sc_hd__decap_3
X_2330_ _2009_ _2022_ _2024_ VGND VGND VPWR VPWR _2029_ sky130_fd_sc_hd__a21o_1
X_2261_ _1937_ _1958_ _1959_ VGND VGND VPWR VPWR _1960_ sky130_fd_sc_hd__or3_1
X_4000_ _1849_ _1850_ _1851_ VGND VGND VPWR VPWR _0266_ sky130_fd_sc_hd__and3b_1
X_2192_ systolic_unit_0.U_11.acc_0\[4\] systolic_unit_0.U_11.acc_1\[4\] net146 VGND
+ VGND VPWR VPWR _1896_ sky130_fd_sc_hd__mux2_1
XFILLER_37_135 VGND VGND VPWR VPWR sky130_fd_sc_hd__fill_1
XTAP_TAPCELL_ROW_48_653 VGND VPWR sky130_fd_sc_hd__tapvpwrvgnd_1
XFILLER_25_319 VGND VGND VPWR VPWR sky130_fd_sc_hd__fill_1
XFILLER_80_458 VGND VGND VPWR VPWR sky130_fd_sc_hd__decap_3
XFILLER_33_330 VGND VGND VPWR VPWR sky130_fd_sc_hd__decap_6
X_3715_ _1576_ _1591_ VGND VGND VPWR VPWR _1604_ sky130_fd_sc_hd__xnor2_1
X_3646_ _1523_ _1534_ VGND VGND VPWR VPWR _1535_ sky130_fd_sc_hd__nor2_1
X_3577_ _1460_ _1465_ VGND VGND VPWR VPWR _1466_ sky130_fd_sc_hd__and2_1
XTAP_TAPCELL_ROW_93_1084 VGND VPWR sky130_fd_sc_hd__tapvpwrvgnd_1
XFILLER_88_525 VGND VGND VPWR VPWR sky130_fd_sc_hd__decap_6
XFILLER_0_418 VGND VGND VPWR VPWR sky130_fd_sc_hd__fill_2
X_2528_ _0506_ _0510_ _0512_ VGND VGND VPWR VPWR _0513_ sky130_fd_sc_hd__nor3_1
XTAP_TAPCELL_ROW_93_1095 VGND VPWR sky130_fd_sc_hd__tapvpwrvgnd_1
XFILLER_29_15 VGND VGND VPWR VPWR sky130_fd_sc_hd__decap_4
Xhold26 systolic_unit_0.U_10.acc_1\[1\] VGND VGND VPWR VPWR net301 sky130_fd_sc_hd__dlygate4sd3_1
Xhold37 systolic_unit_0.U_10.acc_1\[6\] VGND VGND VPWR VPWR net312 sky130_fd_sc_hd__dlygate4sd3_1
X_2459_ _0440_ _0442_ _0443_ VGND VGND VPWR VPWR _0444_ sky130_fd_sc_hd__nand3_1
Xhold48 systolic_unit_0.U_10.acc_0\[2\] VGND VGND VPWR VPWR net323 sky130_fd_sc_hd__dlygate4sd3_1
XTAP_TAPCELL_ROW_3_234 VGND VPWR sky130_fd_sc_hd__tapvpwrvgnd_1
Xhold59 net47 VGND VGND VPWR VPWR net334 sky130_fd_sc_hd__dlygate4sd3_1
X_4129_ net223 VGND VGND VPWR VPWR _0110_ sky130_fd_sc_hd__inv_2
XFILLER_56_444 VGND VGND VPWR VPWR sky130_fd_sc_hd__fill_1
XFILLER_83_252 VPWR VGND VPWR VGND sky130_ef_sc_hd__decap_12
XFILLER_56_477 VGND VGND VPWR VPWR sky130_fd_sc_hd__decap_8
XFILLER_71_447 VGND VGND VPWR VPWR sky130_fd_sc_hd__fill_1
XTAP_TAPCELL_ROW_82_976 VGND VPWR sky130_fd_sc_hd__tapvpwrvgnd_1
XFILLER_24_363 VGND VGND VPWR VPWR sky130_fd_sc_hd__fill_1
XFILLER_12_525 VGND VGND VPWR VPWR sky130_fd_sc_hd__decap_6
XFILLER_61_79 VPWR VGND VPWR VGND sky130_ef_sc_hd__decap_12
XFILLER_3_223 VGND VGND VPWR VPWR sky130_fd_sc_hd__fill_1
XFILLER_86_65 VPWR VGND VPWR VGND sky130_ef_sc_hd__decap_12
XFILLER_19_113 VPWR VGND VPWR VGND sky130_ef_sc_hd__decap_12
XFILLER_34_105 VGND VGND VPWR VPWR sky130_fd_sc_hd__decap_8
XFILLER_62_436 VGND VGND VPWR VPWR sky130_fd_sc_hd__decap_3
XFILLER_62_458 VPWR VGND VPWR VGND sky130_ef_sc_hd__decap_12
XFILLER_30_355 VGND VGND VPWR VPWR sky130_fd_sc_hd__decap_8
XFILLER_30_388 VPWR VGND VPWR VGND sky130_ef_sc_hd__decap_12
X_3500_ drain_odd net142 VGND VGND VPWR VPWR _1405_ sky130_fd_sc_hd__and2_2
X_4480_ clknet_leaf_0_clk net314 _0204_ VGND VGND VPWR VPWR systolic_unit_0.out_acc_1_r1\[11\]
+ sky130_fd_sc_hd__dfrtp_1
X_3431_ _1346_ _1351_ VGND VGND VPWR VPWR _1352_ sky130_fd_sc_hd__xnor2_1
X_3362_ _1281_ _1282_ VGND VGND VPWR VPWR _1283_ sky130_fd_sc_hd__and2b_1
X_2313_ _1985_ _2002_ _2007_ VGND VGND VPWR VPWR _2012_ sky130_fd_sc_hd__a21o_1
XFILLER_85_517 VPWR VGND VPWR VGND sky130_ef_sc_hd__decap_12
X_3293_ _1177_ _1178_ _1179_ VGND VGND VPWR VPWR _1214_ sky130_fd_sc_hd__a21o_1
X_2244_ _1924_ _1929_ _1941_ VGND VGND VPWR VPWR _1943_ sky130_fd_sc_hd__or3_1
X_2175_ net351 _1887_ net92 VGND VGND VPWR VPWR _0398_ sky130_fd_sc_hd__mux2_1
XPHY_EDGE_ROW_69_Left_163 VGND VGND VPWR VPWR sky130_fd_sc_hd__decap_3
XTAP_TAPCELL_ROW_0_204 VGND VPWR sky130_fd_sc_hd__tapvpwrvgnd_1
XFILLER_65_274 VGND VGND VPWR VPWR sky130_fd_sc_hd__decap_6
XFILLER_80_233 VPWR VGND VPWR VGND sky130_ef_sc_hd__decap_12
XFILLER_25_149 VPWR VGND VPWR VGND sky130_ef_sc_hd__decap_12
XFILLER_21_333 VGND VGND VPWR VPWR sky130_fd_sc_hd__decap_3
XFILLER_21_344 VGND VGND VPWR VPWR sky130_fd_sc_hd__decap_8
XFILLER_21_366 VPWR VGND VPWR VGND sky130_ef_sc_hd__decap_12
XPHY_EDGE_ROW_78_Left_172 VGND VGND VPWR VPWR sky130_fd_sc_hd__decap_3
X_3629_ _1481_ _1482_ VGND VGND VPWR VPWR _1518_ sky130_fd_sc_hd__xnor2_1
Xoutput49 net49 VGND VGND VPWR VPWR D_c_flat[19] sky130_fd_sc_hd__buf_2
XFILLER_0_237 VGND VGND VPWR VPWR sky130_fd_sc_hd__decap_8
XFILLER_0_259 VGND VGND VPWR VPWR sky130_fd_sc_hd__decap_8
XPHY_EDGE_ROW_87_Left_181 VGND VGND VPWR VPWR sky130_fd_sc_hd__decap_3
XFILLER_29_455 VPWR VGND VPWR VGND sky130_ef_sc_hd__decap_12
XTAP_TAPCELL_ROW_59_759 VGND VPWR sky130_fd_sc_hd__tapvpwrvgnd_1
XFILLER_29_488 VGND VGND VPWR VPWR sky130_fd_sc_hd__decap_8
XFILLER_71_266 VGND VGND VPWR VPWR sky130_fd_sc_hd__fill_1
XTAP_TAPCELL_ROW_42_604 VGND VPWR sky130_fd_sc_hd__tapvpwrvgnd_1
XFILLER_72_67 VGND VGND VPWR VPWR sky130_fd_sc_hd__decap_8
XTAP_TAPCELL_ROW_14_339 VGND VPWR sky130_fd_sc_hd__tapvpwrvgnd_1
XFILLER_12_377 VPWR VGND VPWR VGND sky130_ef_sc_hd__decap_12
XFILLER_8_326 VGND VGND VPWR VPWR sky130_fd_sc_hd__decap_8
XTAP_TAPCELL_ROW_50_681 VGND VPWR sky130_fd_sc_hd__tapvpwrvgnd_1
XFILLER_67_517 VPWR VGND VPWR VGND sky130_ef_sc_hd__decap_12
XFILLER_90_531 VGND VGND VPWR VPWR sky130_fd_sc_hd__fill_1
XFILLER_35_447 VGND VGND VPWR VPWR sky130_fd_sc_hd__fill_1
XFILLER_90_553 VGND VGND VPWR VPWR sky130_fd_sc_hd__fill_1
XFILLER_35_469 VGND VGND VPWR VPWR sky130_fd_sc_hd__decap_4
X_3980_ systolic_unit_0.U_11.acc_1\[4\] net74 net81 systolic_unit_0.U_01.acc_1\[4\]
+ VGND VGND VPWR VPWR _1842_ sky130_fd_sc_hd__a22o_1
X_2931_ _0873_ _0876_ _0879_ VGND VGND VPWR VPWR _0884_ sky130_fd_sc_hd__or3_1
Xclkbuf_0_clk clk VGND VGND VPWR VPWR clknet_0_clk sky130_fd_sc_hd__clkbuf_16
XFILLER_87_3 VPWR VGND VPWR VGND sky130_ef_sc_hd__decap_12
X_2862_ net176 net122 VGND VGND VPWR VPWR _0815_ sky130_fd_sc_hd__nand2_1
XFILLER_30_141 VGND VGND VPWR VPWR sky130_fd_sc_hd__decap_6
X_2793_ net129 net168 VGND VGND VPWR VPWR _0746_ sky130_fd_sc_hd__nand2_1
XFILLER_7_51 VGND VGND VPWR VPWR sky130_fd_sc_hd__decap_4
X_4463_ clknet_leaf_0_clk _0412_ _0187_ VGND VGND VPWR VPWR net41 sky130_fd_sc_hd__dfrtp_1
X_3414_ _1329_ _1334_ VGND VGND VPWR VPWR _1335_ sky130_fd_sc_hd__nand2_1
XPHY_EDGE_ROW_15_Right_15 VGND VGND VPWR VPWR sky130_fd_sc_hd__decap_3
X_4394_ clknet_leaf_3_clk _0367_ _0118_ VGND VGND VPWR VPWR systolic_unit_0.U_00.acc_1\[14\]
+ sky130_fd_sc_hd__dfrtp_1
XTAP_TAPCELL_ROW_90_1054 VGND VPWR sky130_fd_sc_hd__tapvpwrvgnd_1
X_3345_ _1263_ _1264_ _1265_ VGND VGND VPWR VPWR _1266_ sky130_fd_sc_hd__and3_1
X_3276_ _1158_ _1196_ VGND VGND VPWR VPWR _1197_ sky130_fd_sc_hd__nor2_1
X_2227_ _1925_ net212 net262 VGND VGND VPWR VPWR _1926_ sky130_fd_sc_hd__and3b_1
XTAP_TAPCELL_ROW_56_729 VGND VPWR sky130_fd_sc_hd__tapvpwrvgnd_1
XFILLER_93_391 VGND VGND VPWR VPWR sky130_fd_sc_hd__fill_1
X_2158_ systolic_unit_0.out_acc_0_r1\[5\] systolic_unit_0.out_acc_1_r1\[5\] net143
+ VGND VGND VPWR VPWR _1879_ sky130_fd_sc_hd__mux2_1
XFILLER_26_27 VGND VGND VPWR VPWR sky130_fd_sc_hd__fill_1
XFILLER_38_296 VPWR VGND VPWR VGND sky130_ef_sc_hd__decap_12
XFILLER_53_222 VGND VGND VPWR VPWR sky130_fd_sc_hd__fill_2
XFILLER_81_553 VGND VGND VPWR VPWR sky130_fd_sc_hd__fill_1
XPHY_EDGE_ROW_24_Right_24 VGND VGND VPWR VPWR sky130_fd_sc_hd__decap_3
XFILLER_26_49 VGND VGND VPWR VPWR sky130_fd_sc_hd__fill_1
XFILLER_26_458 VGND VGND VPWR VPWR sky130_fd_sc_hd__decap_4
XTAP_TAPCELL_ROW_11_309 VGND VPWR sky130_fd_sc_hd__tapvpwrvgnd_1
XFILLER_42_37 VPWR VGND VPWR VGND sky130_ef_sc_hd__decap_12
XPHY_EDGE_ROW_33_Right_33 VGND VGND VPWR VPWR sky130_fd_sc_hd__decap_3
XFILLER_88_141 VPWR VGND VPWR VGND sky130_ef_sc_hd__decap_12
XFILLER_76_314 VGND VGND VPWR VPWR sky130_fd_sc_hd__decap_4
XFILLER_49_517 VGND VGND VPWR VPWR sky130_fd_sc_hd__decap_3
XFILLER_91_328 VGND VGND VPWR VPWR sky130_fd_sc_hd__decap_8
XFILLER_72_531 VGND VGND VPWR VPWR sky130_fd_sc_hd__fill_1
XPHY_EDGE_ROW_42_Right_42 VGND VGND VPWR VPWR sky130_fd_sc_hd__decap_3
XFILLER_83_55 VGND VGND VPWR VPWR sky130_fd_sc_hd__fill_1
XFILLER_72_553 VGND VGND VPWR VPWR sky130_fd_sc_hd__fill_1
XFILLER_32_406 VGND VGND VPWR VPWR sky130_fd_sc_hd__fill_1
XFILLER_32_428 VPWR VGND VPWR VGND sky130_ef_sc_hd__decap_12
XFILLER_12_141 VPWR VGND VPWR VGND sky130_ef_sc_hd__decap_12
XPHY_EDGE_ROW_51_Right_51 VGND VGND VPWR VPWR sky130_fd_sc_hd__decap_3
XFILLER_8_189 VGND VGND VPWR VPWR sky130_fd_sc_hd__decap_6
XFILLER_4_395 VPWR VGND VPWR VGND sky130_ef_sc_hd__decap_12
XFILLER_79_163 VGND VGND VPWR VPWR sky130_fd_sc_hd__decap_4
X_3130_ _1042_ _1049_ VGND VGND VPWR VPWR _1051_ sky130_fd_sc_hd__nand2_1
XFILLER_82_306 VGND VGND VPWR VPWR sky130_fd_sc_hd__fill_2
X_3061_ _0980_ _0981_ VGND VGND VPWR VPWR _0982_ sky130_fd_sc_hd__nand2_1
XPHY_EDGE_ROW_60_Right_60 VGND VGND VPWR VPWR sky130_fd_sc_hd__decap_3
XFILLER_75_391 VGND VGND VPWR VPWR sky130_fd_sc_hd__fill_1
XFILLER_35_222 VGND VGND VPWR VPWR sky130_fd_sc_hd__fill_2
XFILLER_90_383 VPWR VGND VPWR VGND sky130_ef_sc_hd__decap_12
XFILLER_35_266 VGND VGND VPWR VPWR sky130_fd_sc_hd__fill_2
X_3963_ net98 _1792_ _1833_ VGND VGND VPWR VPWR _0258_ sky130_fd_sc_hd__a21o_1
X_2914_ _0843_ _0865_ VGND VGND VPWR VPWR _0867_ sky130_fd_sc_hd__xnor2_1
X_3894_ _1777_ _1782_ VGND VGND VPWR VPWR _1783_ sky130_fd_sc_hd__xnor2_1
X_2845_ net173 net122 _0790_ _0789_ VGND VGND VPWR VPWR _0798_ sky130_fd_sc_hd__a31o_1
XFILLER_12_29 VGND VGND VPWR VPWR sky130_fd_sc_hd__decap_8
X_2776_ _0701_ _0717_ VGND VGND VPWR VPWR _0729_ sky130_fd_sc_hd__xnor2_1
X_4515_ clknet_leaf_25_clk net11 _0239_ VGND VGND VPWR VPWR systolic_unit_0.U_10.in_a\[2\]
+ sky130_fd_sc_hd__dfrtp_1
Xhold101 systolic_unit_0.U_00.acc_0\[15\] VGND VGND VPWR VPWR net376 sky130_fd_sc_hd__dlygate4sd3_1
Xhold123 systolic_unit_0.U_01.acc_1\[12\] VGND VGND VPWR VPWR net398 sky130_fd_sc_hd__dlygate4sd3_1
Xhold112 systolic_unit_0.U_01.acc_1\[5\] VGND VGND VPWR VPWR net387 sky130_fd_sc_hd__dlygate4sd3_1
Xhold134 systolic_unit_0.U_00.acc_0\[2\] VGND VGND VPWR VPWR net409 sky130_fd_sc_hd__dlygate4sd3_1
X_4446_ clknet_leaf_28_clk net269 _0170_ VGND VGND VPWR VPWR systolic_unit_0.U_00.out_b\[2\]
+ sky130_fd_sc_hd__dfrtp_2
Xhold145 _0245_ VGND VGND VPWR VPWR net420 sky130_fd_sc_hd__dlygate4sd3_1
Xhold156 systolic_unit_0.U_01.acc_0\[11\] VGND VGND VPWR VPWR net431 sky130_fd_sc_hd__dlygate4sd3_1
X_4377_ clknet_leaf_15_clk _0350_ _0101_ VGND VGND VPWR VPWR systolic_unit_0.U_01.acc_0\[13\]
+ sky130_fd_sc_hd__dfrtp_1
X_3328_ _1248_ VGND VGND VPWR VPWR _1249_ sky130_fd_sc_hd__inv_2
XFILLER_85_111 VGND VGND VPWR VPWR sky130_fd_sc_hd__fill_1
XTAP_TAPCELL_ROW_69_854 VGND VPWR sky130_fd_sc_hd__tapvpwrvgnd_1
XFILLER_37_15 VGND VGND VPWR VPWR sky130_fd_sc_hd__fill_1
X_3259_ _1177_ _1178_ _1179_ VGND VGND VPWR VPWR _1180_ sky130_fd_sc_hd__and3_1
XTAP_TAPCELL_ROW_24_434 VGND VPWR sky130_fd_sc_hd__tapvpwrvgnd_1
XFILLER_41_225 VPWR VGND VPWR VGND sky130_ef_sc_hd__decap_12
XFILLER_53_69 VPWR VGND VPWR VGND sky130_ef_sc_hd__decap_12
XFILLER_91_125 VPWR VGND VPWR VGND sky130_ef_sc_hd__decap_12
XFILLER_76_188 VGND VGND VPWR VPWR sky130_fd_sc_hd__decap_8
XFILLER_91_169 VPWR VGND VPWR VGND sky130_ef_sc_hd__decap_12
XFILLER_13_461 VPWR VGND VPWR VGND sky130_ef_sc_hd__decap_12
XFILLER_32_258 VPWR VGND VPWR VGND sky130_ef_sc_hd__decap_12
XFILLER_71_6 VGND VGND VPWR VPWR sky130_fd_sc_hd__decap_4
X_2630_ net99 _0580_ net79 systolic_unit_0.U_00.acc_1\[7\] VGND VGND VPWR VPWR _0360_
+ sky130_fd_sc_hd__a22o_1
X_2561_ _0545_ VGND VGND VPWR VPWR _0546_ sky130_fd_sc_hd__inv_2
X_4300_ clknet_leaf_21_clk _0281_ _0024_ VGND VGND VPWR VPWR systolic_unit_0.U_11.acc_0\[8\]
+ sky130_fd_sc_hd__dfrtp_1
X_2492_ systolic_unit_0.U_00.acc_1\[3\] systolic_unit_0.U_00.acc_0\[3\] net210 VGND
+ VGND VPWR VPWR _0477_ sky130_fd_sc_hd__mux2_1
X_4231_ net237 VGND VGND VPWR VPWR _0212_ sky130_fd_sc_hd__inv_2
XFILLER_4_41 VPWR VGND VPWR VGND sky130_ef_sc_hd__decap_12
XFILLER_4_85 VPWR VGND VPWR VGND sky130_ef_sc_hd__decap_12
X_4162_ net230 VGND VGND VPWR VPWR _0143_ sky130_fd_sc_hd__inv_2
X_3113_ _1020_ _1033_ VGND VGND VPWR VPWR _1034_ sky130_fd_sc_hd__nor2_1
X_4093_ net243 VGND VGND VPWR VPWR _0074_ sky130_fd_sc_hd__inv_2
X_3044_ net94 _0960_ net77 net367 VGND VGND VPWR VPWR _0332_ sky130_fd_sc_hd__a22o_1
XTAP_TAPCELL_ROW_66_824 VGND VPWR sky130_fd_sc_hd__tapvpwrvgnd_1
XFILLER_36_531 VGND VGND VPWR VPWR sky130_fd_sc_hd__fill_1
XFILLER_36_553 VGND VGND VPWR VPWR sky130_fd_sc_hd__fill_1
XTAP_TAPCELL_ROW_38_559 VGND VPWR sky130_fd_sc_hd__tapvpwrvgnd_1
XFILLER_63_361 VGND VGND VPWR VPWR sky130_fd_sc_hd__decap_4
XFILLER_23_225 VGND VGND VPWR VPWR sky130_fd_sc_hd__fill_2
X_3946_ systolic_unit_0.U_01.acc_0\[2\] net75 net82 systolic_unit_0.U_11.acc_0\[2\]
+ VGND VGND VPWR VPWR _1822_ sky130_fd_sc_hd__a22o_1
XTAP_TAPCELL_ROW_21_404 VGND VPWR sky130_fd_sc_hd__tapvpwrvgnd_1
X_3877_ _1643_ _1644_ _1761_ _1762_ VGND VGND VPWR VPWR _1766_ sky130_fd_sc_hd__o22a_1
X_2828_ systolic_unit_0.U_01.acc_1\[5\] systolic_unit_0.U_01.acc_0\[5\] net141 VGND
+ VGND VPWR VPWR _0781_ sky130_fd_sc_hd__mux2_1
X_2759_ net125 net167 systolic_unit_0.U_00.out_a\[6\] net127 VGND VGND VPWR VPWR _0712_
+ sky130_fd_sc_hd__a22oi_1
XFILLER_2_129 VGND VGND VPWR VPWR sky130_fd_sc_hd__decap_3
X_4429_ clknet_leaf_16_clk _0386_ _0153_ VGND VGND VPWR VPWR net47 sky130_fd_sc_hd__dfrtp_1
XFILLER_48_47 VPWR VGND VPWR VGND sky130_ef_sc_hd__decap_12
XFILLER_86_475 VGND VGND VPWR VPWR sky130_fd_sc_hd__fill_1
XFILLER_46_306 VGND VGND VPWR VPWR sky130_fd_sc_hd__fill_2
XFILLER_27_542 VPWR VGND VPWR VGND sky130_ef_sc_hd__decap_12
XFILLER_73_169 VPWR VGND VPWR VGND sky130_ef_sc_hd__decap_12
XPHY_EDGE_ROW_14_Left_108 VGND VGND VPWR VPWR sky130_fd_sc_hd__decap_3
XFILLER_54_350 VGND VGND VPWR VPWR sky130_fd_sc_hd__fill_2
XFILLER_81_191 VPWR VGND VPWR VGND sky130_ef_sc_hd__decap_12
XFILLER_14_214 VGND VGND VPWR VPWR sky130_fd_sc_hd__decap_8
XFILLER_54_383 VGND VGND VPWR VPWR sky130_fd_sc_hd__decap_8
Xfanout84 _0591_ VGND VGND VPWR VPWR net84 sky130_fd_sc_hd__clkbuf_4
Xfanout95 net96 VGND VGND VPWR VPWR net95 sky130_fd_sc_hd__buf_2
XFILLER_10_475 VGND VGND VPWR VPWR sky130_fd_sc_hd__fill_1
XFILLER_6_413 VGND VGND VPWR VPWR sky130_fd_sc_hd__decap_6
XFILLER_6_457 VPWR VGND VPWR VGND sky130_ef_sc_hd__decap_12
XPHY_EDGE_ROW_23_Left_117 VGND VGND VPWR VPWR sky130_fd_sc_hd__decap_3
XTAP_TAPCELL_ROW_9_284 VGND VPWR sky130_fd_sc_hd__tapvpwrvgnd_1
XFILLER_36_9 VGND VGND VPWR VPWR sky130_fd_sc_hd__fill_1
XFILLER_77_431 VGND VGND VPWR VPWR sky130_fd_sc_hd__fill_2
XFILLER_49_144 VGND VGND VPWR VPWR sky130_fd_sc_hd__fill_2
XFILLER_92_401 VGND VGND VPWR VPWR sky130_fd_sc_hd__decap_8
XFILLER_92_445 VPWR VGND VPWR VGND sky130_ef_sc_hd__decap_12
XFILLER_18_553 VGND VGND VPWR VPWR sky130_fd_sc_hd__fill_1
XPHY_EDGE_ROW_32_Left_126 VGND VGND VPWR VPWR sky130_fd_sc_hd__decap_3
XFILLER_92_489 VPWR VGND VPWR VGND sky130_ef_sc_hd__decap_12
XFILLER_52_309 VPWR VGND VPWR VGND sky130_ef_sc_hd__decap_12
XFILLER_72_180 VPWR VGND VPWR VGND sky130_ef_sc_hd__decap_12
XFILLER_45_383 VGND VGND VPWR VPWR sky130_fd_sc_hd__fill_1
X_3800_ _1630_ _1688_ VGND VGND VPWR VPWR _1689_ sky130_fd_sc_hd__and2_1
X_3731_ net187 net196 _1619_ _1617_ VGND VGND VPWR VPWR _1620_ sky130_fd_sc_hd__a31o_1
X_3662_ _1546_ _1548_ _1549_ VGND VGND VPWR VPWR _1551_ sky130_fd_sc_hd__and3_1
XPHY_EDGE_ROW_41_Left_135 VGND VGND VPWR VPWR sky130_fd_sc_hd__decap_3
Xclkload10 clknet_leaf_4_clk VGND VGND VPWR VPWR clkload10/Y sky130_fd_sc_hd__inv_6
X_3593_ net199 net178 VGND VGND VPWR VPWR _1482_ sky130_fd_sc_hd__nand2_1
X_2613_ _0503_ _0506_ _0513_ VGND VGND VPWR VPWR _0585_ sky130_fd_sc_hd__nor3_1
Xclkload21 clknet_leaf_11_clk VGND VGND VPWR VPWR clkload21/X sky130_fd_sc_hd__clkbuf_4
X_2544_ _0526_ _0527_ VGND VGND VPWR VPWR _0529_ sky130_fd_sc_hd__xnor2_1
X_2475_ _0427_ _0451_ net87 VGND VGND VPWR VPWR _0460_ sky130_fd_sc_hd__a21o_1
X_4214_ net238 VGND VGND VPWR VPWR _0195_ sky130_fd_sc_hd__inv_2
X_4145_ net247 VGND VGND VPWR VPWR _0126_ sky130_fd_sc_hd__inv_2
XFILLER_68_464 VGND VGND VPWR VPWR sky130_fd_sc_hd__decap_4
XFILLER_83_412 VGND VGND VPWR VPWR sky130_fd_sc_hd__decap_3
XPHY_EDGE_ROW_50_Left_144 VGND VGND VPWR VPWR sky130_fd_sc_hd__decap_3
XFILLER_55_125 VPWR VGND VPWR VGND sky130_ef_sc_hd__decap_12
XTAP_TAPCELL_ROW_87_1026 VGND VPWR sky130_fd_sc_hd__tapvpwrvgnd_1
XFILLER_83_445 VGND VGND VPWR VPWR sky130_fd_sc_hd__decap_3
X_4076_ net224 VGND VGND VPWR VPWR _0057_ sky130_fd_sc_hd__inv_2
X_3027_ _0905_ _0919_ _0968_ VGND VGND VPWR VPWR _0969_ sky130_fd_sc_hd__nor3_1
XFILLER_55_169 VGND VGND VPWR VPWR sky130_fd_sc_hd__decap_8
XFILLER_24_523 VGND VGND VPWR VPWR sky130_fd_sc_hd__decap_8
XFILLER_24_545 VGND VGND VPWR VPWR sky130_fd_sc_hd__decap_8
XFILLER_11_217 VGND VGND VPWR VPWR sky130_fd_sc_hd__decap_6
Xclkload4 clknet_leaf_2_clk VGND VGND VPWR VPWR clkload4/Y sky130_fd_sc_hd__clkinv_8
X_3929_ net391 net75 _1808_ net145 _1809_ VGND VGND VPWR VPWR _0280_ sky130_fd_sc_hd__a221o_1
XFILLER_50_26 VGND VGND VPWR VPWR sky130_fd_sc_hd__fill_2
XFILLER_3_405 VPWR VGND VPWR VGND sky130_ef_sc_hd__decap_12
XFILLER_3_449 VPWR VGND VPWR VGND sky130_ef_sc_hd__decap_12
XFILLER_78_217 VPWR VGND VPWR VGND sky130_ef_sc_hd__decap_12
Xfanout241 net242 VGND VGND VPWR VPWR net241 sky130_fd_sc_hd__buf_4
Xfanout230 net231 VGND VGND VPWR VPWR net230 sky130_fd_sc_hd__buf_4
XFILLER_93_209 VGND VGND VPWR VPWR sky130_fd_sc_hd__decap_8
Xfanout263 net21 VGND VGND VPWR VPWR net263 sky130_fd_sc_hd__buf_2
XTAP_TAPCELL_ROW_6_254 VGND VPWR sky130_fd_sc_hd__tapvpwrvgnd_1
Xfanout252 net253 VGND VGND VPWR VPWR net252 sky130_fd_sc_hd__clkbuf_2
Xfanout274 net275 VGND VGND VPWR VPWR net274 sky130_fd_sc_hd__buf_2
XFILLER_86_283 VPWR VGND VPWR VGND sky130_ef_sc_hd__decap_12
XFILLER_86_261 VGND VGND VPWR VPWR sky130_fd_sc_hd__decap_3
XFILLER_74_401 VGND VGND VPWR VPWR sky130_fd_sc_hd__decap_4
XFILLER_75_78 VPWR VGND VPWR VGND sky130_ef_sc_hd__decap_12
XFILLER_74_489 VPWR VGND VPWR VGND sky130_ef_sc_hd__decap_12
XFILLER_91_55 VGND VGND VPWR VPWR sky130_fd_sc_hd__fill_1
XFILLER_54_191 VGND VGND VPWR VPWR sky130_fd_sc_hd__decap_4
XFILLER_30_526 VGND VGND VPWR VPWR sky130_fd_sc_hd__decap_6
XFILLER_10_283 VGND VGND VPWR VPWR sky130_fd_sc_hd__fill_1
XFILLER_6_221 VGND VGND VPWR VPWR sky130_fd_sc_hd__decap_8
XFILLER_6_287 VGND VGND VPWR VPWR sky130_fd_sc_hd__decap_6
XFILLER_41_7 VGND VGND VPWR VPWR sky130_fd_sc_hd__decap_4
X_2260_ _1948_ _1950_ _1947_ VGND VGND VPWR VPWR _1959_ sky130_fd_sc_hd__a21boi_1
XFILLER_84_209 VPWR VGND VPWR VGND sky130_ef_sc_hd__decap_12
X_2191_ net422 _1895_ net92 VGND VGND VPWR VPWR _0390_ sky130_fd_sc_hd__mux2_1
XFILLER_92_253 VGND VGND VPWR VPWR sky130_fd_sc_hd__fill_2
XFILLER_37_169 VPWR VGND VPWR VGND sky130_ef_sc_hd__decap_12
XTAP_TAPCELL_ROW_48_654 VGND VPWR sky130_fd_sc_hd__tapvpwrvgnd_1
XFILLER_52_117 VGND VGND VPWR VPWR sky130_fd_sc_hd__fill_1
X_3714_ _1597_ _1602_ VGND VGND VPWR VPWR _1603_ sky130_fd_sc_hd__xnor2_1
XFILLER_20_29 VPWR VGND VPWR VGND sky130_ef_sc_hd__decap_12
X_3645_ _1521_ _1522_ VGND VGND VPWR VPWR _1534_ sky130_fd_sc_hd__nor2_1
X_3576_ _1454_ _1459_ VGND VGND VPWR VPWR _1465_ sky130_fd_sc_hd__nand2_1
XTAP_TAPCELL_ROW_93_1085 VGND VPWR sky130_fd_sc_hd__tapvpwrvgnd_1
X_2527_ net272 net274 _0511_ VGND VGND VPWR VPWR _0512_ sky130_fd_sc_hd__nand3_1
XTAP_TAPCELL_ROW_93_1096 VGND VPWR sky130_fd_sc_hd__tapvpwrvgnd_1
X_2458_ _2101_ _0441_ _0417_ _2129_ VGND VGND VPWR VPWR _0443_ sky130_fd_sc_hd__o211ai_1
XPHY_EDGE_ROW_89_Right_89 VGND VGND VPWR VPWR sky130_fd_sc_hd__decap_3
Xhold38 systolic_unit_0.U_10.acc_0\[3\] VGND VGND VPWR VPWR net313 sky130_fd_sc_hd__dlygate4sd3_1
Xhold27 systolic_unit_0.U_10.acc_1\[15\] VGND VGND VPWR VPWR net302 sky130_fd_sc_hd__dlygate4sd3_1
XFILLER_68_250 VGND VGND VPWR VPWR sky130_fd_sc_hd__fill_2
Xhold49 drain_odd_d1 VGND VGND VPWR VPWR net324 sky130_fd_sc_hd__dlygate4sd3_1
X_2389_ _2084_ _2087_ VGND VGND VPWR VPWR _2088_ sky130_fd_sc_hd__xnor2_1
X_4128_ net233 VGND VGND VPWR VPWR _0109_ sky130_fd_sc_hd__inv_2
XFILLER_83_264 VPWR VGND VPWR VGND sky130_ef_sc_hd__decap_12
X_4059_ net227 VGND VGND VPWR VPWR _0040_ sky130_fd_sc_hd__inv_2
XFILLER_45_15 VGND VGND VPWR VPWR sky130_fd_sc_hd__decap_3
XFILLER_45_48 VGND VGND VPWR VPWR sky130_fd_sc_hd__fill_1
XTAP_TAPCELL_ROW_82_977 VGND VPWR sky130_fd_sc_hd__tapvpwrvgnd_1
XFILLER_61_47 VGND VGND VPWR VPWR sky130_fd_sc_hd__fill_2
XFILLER_10_73 VGND VGND VPWR VPWR sky130_fd_sc_hd__fill_1
XFILLER_86_77 VGND VGND VPWR VPWR sky130_fd_sc_hd__decap_6
XFILLER_74_253 VPWR VGND VPWR VGND sky130_ef_sc_hd__decap_12
XFILLER_62_404 VGND VGND VPWR VPWR sky130_fd_sc_hd__decap_4
XTAP_TAPCELL_ROW_17_359 VGND VPWR sky130_fd_sc_hd__tapvpwrvgnd_1
XFILLER_35_92 VPWR VGND VPWR VGND sky130_ef_sc_hd__decap_12
XFILLER_42_150 VGND VGND VPWR VPWR sky130_fd_sc_hd__decap_4
XFILLER_7_541 VPWR VGND VPWR VGND sky130_ef_sc_hd__decap_12
X_3430_ _1006_ _1350_ VGND VGND VPWR VPWR _1351_ sky130_fd_sc_hd__xnor2_1
X_3361_ _1248_ _1260_ _1275_ _1279_ VGND VGND VPWR VPWR _1282_ sky130_fd_sc_hd__a211o_1
X_2312_ _2009_ _2010_ VGND VGND VPWR VPWR _2011_ sky130_fd_sc_hd__nor2_1
X_3292_ _1177_ _1178_ _1179_ VGND VGND VPWR VPWR _1213_ sky130_fd_sc_hd__a21oi_1
XFILLER_85_529 VPWR VGND VPWR VGND sky130_ef_sc_hd__decap_12
X_2243_ _1929_ _1941_ _1924_ VGND VGND VPWR VPWR _1942_ sky130_fd_sc_hd__o21ai_1
X_2174_ systolic_unit_0.U_11.acc_0\[13\] systolic_unit_0.U_11.acc_1\[13\] net148 VGND
+ VGND VPWR VPWR _1887_ sky130_fd_sc_hd__mux2_1
XFILLER_65_220 VGND VGND VPWR VPWR sky130_fd_sc_hd__decap_4
XTAP_TAPCELL_ROW_0_205 VGND VPWR sky130_fd_sc_hd__tapvpwrvgnd_1
XFILLER_53_404 VGND VGND VPWR VPWR sky130_fd_sc_hd__decap_3
XFILLER_65_242 VPWR VGND VPWR VGND sky130_ef_sc_hd__decap_12
XFILLER_21_378 VPWR VGND VPWR VGND sky130_ef_sc_hd__decap_12
X_3628_ _1506_ _1508_ VGND VGND VPWR VPWR _1517_ sky130_fd_sc_hd__nor2_1
Xoutput39 net39 VGND VGND VPWR VPWR D_c_flat[0] sky130_fd_sc_hd__buf_2
X_3559_ systolic_unit_0.U_11.acc_1\[12\] systolic_unit_0.U_11.acc_0\[12\] net148 VGND
+ VGND VPWR VPWR _1448_ sky130_fd_sc_hd__mux2_1
XFILLER_48_209 VGND VGND VPWR VPWR sky130_fd_sc_hd__decap_6
XFILLER_29_467 VGND VGND VPWR VPWR sky130_fd_sc_hd__decap_4
XFILLER_29_478 VGND VGND VPWR VPWR sky130_fd_sc_hd__decap_3
XFILLER_56_253 VPWR VGND VPWR VGND sky130_ef_sc_hd__decap_12
XFILLER_71_201 VPWR VGND VPWR VGND sky130_ef_sc_hd__decap_12
XTAP_TAPCELL_ROW_42_605 VGND VPWR sky130_fd_sc_hd__tapvpwrvgnd_1
XFILLER_12_389 VPWR VGND VPWR VGND sky130_ef_sc_hd__decap_12
XFILLER_4_533 VPWR VGND VPWR VGND sky130_ef_sc_hd__decap_12
XFILLER_67_529 VPWR VGND VPWR VGND sky130_ef_sc_hd__decap_12
XFILLER_35_404 VPWR VGND VPWR VGND sky130_ef_sc_hd__decap_12
XFILLER_62_201 VGND VGND VPWR VPWR sky130_fd_sc_hd__fill_1
X_2930_ _0881_ _0882_ VGND VGND VPWR VPWR _0883_ sky130_fd_sc_hd__nor2_1
X_2861_ net173 net126 net171 net124 VGND VGND VPWR VPWR _0814_ sky130_fd_sc_hd__and4_1
XFILLER_30_131 VGND VGND VPWR VPWR sky130_fd_sc_hd__decap_8
X_2792_ net131 systolic_unit_0.U_00.out_a\[6\] _0743_ VGND VGND VPWR VPWR _0745_ sky130_fd_sc_hd__and3_1
XFILLER_7_393 VPWR VGND VPWR VGND sky130_ef_sc_hd__decap_12
X_4462_ clknet_leaf_32_clk _0411_ _0186_ VGND VGND VPWR VPWR net40 sky130_fd_sc_hd__dfrtp_1
X_3413_ _1331_ _1332_ VGND VGND VPWR VPWR _1334_ sky130_fd_sc_hd__xor2_1
X_4393_ clknet_leaf_5_clk _0366_ _0117_ VGND VGND VPWR VPWR systolic_unit_0.U_00.acc_1\[13\]
+ sky130_fd_sc_hd__dfrtp_1
XTAP_TAPCELL_ROW_90_1055 VGND VPWR sky130_fd_sc_hd__tapvpwrvgnd_1
X_3344_ systolic_unit_0.U_10.acc_1\[3\] systolic_unit_0.U_10.acc_0\[3\] net137 VGND
+ VGND VPWR VPWR _1265_ sky130_fd_sc_hd__mux2_1
X_3275_ _1156_ _1157_ _1149_ _1151_ VGND VGND VPWR VPWR _1196_ sky130_fd_sc_hd__o211a_1
XFILLER_85_337 VPWR VGND VPWR VGND sky130_ef_sc_hd__decap_12
X_2226_ net264 net215 VGND VGND VPWR VPWR _1925_ sky130_fd_sc_hd__and2_1
XFILLER_38_253 VGND VGND VPWR VPWR sky130_fd_sc_hd__decap_8
X_2157_ net330 _1878_ systolic_unit_0.drain_valid VGND VGND VPWR VPWR _0407_ sky130_fd_sc_hd__mux2_1
XFILLER_42_27 VGND VGND VPWR VPWR sky130_fd_sc_hd__fill_1
XFILLER_42_49 VGND VGND VPWR VPWR sky130_fd_sc_hd__decap_8
XFILLER_21_175 VGND VGND VPWR VPWR sky130_fd_sc_hd__decap_6
XFILLER_1_503 VGND VGND VPWR VPWR sky130_fd_sc_hd__fill_1
XFILLER_88_153 VPWR VGND VPWR VGND sky130_ef_sc_hd__decap_12
XFILLER_49_529 VGND VGND VPWR VPWR sky130_fd_sc_hd__decap_4
XFILLER_67_46 VGND VGND VPWR VPWR sky130_fd_sc_hd__decap_8
XFILLER_67_57 VPWR VGND VPWR VGND sky130_ef_sc_hd__decap_12
XFILLER_88_197 VPWR VGND VPWR VGND sky130_ef_sc_hd__decap_12
XFILLER_76_326 VPWR VGND VPWR VGND sky130_ef_sc_hd__decap_12
XFILLER_44_256 VGND VGND VPWR VPWR sky130_fd_sc_hd__decap_6
XTAP_TAPCELL_ROW_27_454 VGND VPWR sky130_fd_sc_hd__tapvpwrvgnd_1
XFILLER_16_72 VGND VGND VPWR VPWR sky130_fd_sc_hd__decap_4
XFILLER_12_153 VPWR VGND VPWR VGND sky130_ef_sc_hd__decap_12
XFILLER_8_124 VGND VGND VPWR VPWR sky130_fd_sc_hd__fill_2
XFILLER_40_473 VGND VGND VPWR VPWR sky130_fd_sc_hd__decap_3
XFILLER_32_60 VPWR VGND VPWR VGND sky130_ef_sc_hd__decap_12
XFILLER_32_93 VPWR VGND VPWR VGND sky130_ef_sc_hd__decap_12
X_3060_ net104 net153 net102 net154 VGND VGND VPWR VPWR _0981_ sky130_fd_sc_hd__a22o_1
XFILLER_90_362 VGND VGND VPWR VPWR sky130_fd_sc_hd__fill_2
XFILLER_90_395 VGND VGND VPWR VPWR sky130_fd_sc_hd__fill_1
X_3962_ systolic_unit_0.U_11.acc_1\[13\] _1827_ _1830_ systolic_unit_0.U_01.acc_1\[13\]
+ VGND VGND VPWR VPWR _1833_ sky130_fd_sc_hd__a22o_1
X_2913_ _0865_ _0843_ VGND VGND VPWR VPWR _0866_ sky130_fd_sc_hd__nand2b_1
XFILLER_31_440 VGND VGND VPWR VPWR sky130_fd_sc_hd__fill_2
X_3893_ _1778_ _1781_ VGND VGND VPWR VPWR _1782_ sky130_fd_sc_hd__xnor2_1
XTAP_TAPCELL_ROW_61_777 VGND VPWR sky130_fd_sc_hd__tapvpwrvgnd_1
X_2844_ net177 net176 net120 systolic_unit_0.U_01.in_b\[6\] VGND VGND VPWR VPWR _0797_
+ sky130_fd_sc_hd__and4_1
XFILLER_31_473 VPWR VGND VPWR VGND sky130_ef_sc_hd__decap_12
X_2775_ _0722_ _0727_ VGND VGND VPWR VPWR _0728_ sky130_fd_sc_hd__xnor2_1
X_4514_ clknet_leaf_25_clk net10 _0238_ VGND VGND VPWR VPWR systolic_unit_0.U_10.in_a\[1\]
+ sky130_fd_sc_hd__dfrtp_1
Xhold102 systolic_unit_0.U_00.acc_0\[3\] VGND VGND VPWR VPWR net377 sky130_fd_sc_hd__dlygate4sd3_1
Xhold135 systolic_unit_0.U_00.acc_1\[4\] VGND VGND VPWR VPWR net410 sky130_fd_sc_hd__dlygate4sd3_1
Xhold113 systolic_unit_0.U_01.acc_0\[0\] VGND VGND VPWR VPWR net388 sky130_fd_sc_hd__dlygate4sd3_1
Xhold124 systolic_unit_0.U_01.acc_0\[5\] VGND VGND VPWR VPWR net399 sky130_fd_sc_hd__dlygate4sd3_1
Xhold146 systolic_unit_0.U_01.acc_0\[12\] VGND VGND VPWR VPWR net421 sky130_fd_sc_hd__dlygate4sd3_1
X_4445_ clknet_leaf_32_clk net18 _0169_ VGND VGND VPWR VPWR systolic_unit_0.U_00.out_b\[1\]
+ sky130_fd_sc_hd__dfrtp_1
Xhold157 systolic_unit_0.U_01.acc_1\[15\] VGND VGND VPWR VPWR net432 sky130_fd_sc_hd__dlygate4sd3_1
X_4376_ clknet_leaf_15_clk _0349_ _0100_ VGND VGND VPWR VPWR systolic_unit_0.U_01.acc_0\[12\]
+ sky130_fd_sc_hd__dfrtp_1
X_3327_ _1245_ _1246_ _1247_ VGND VGND VPWR VPWR _1248_ sky130_fd_sc_hd__nand3_1
XFILLER_85_167 VGND VGND VPWR VPWR sky130_fd_sc_hd__fill_1
XTAP_TAPCELL_ROW_69_855 VGND VPWR sky130_fd_sc_hd__tapvpwrvgnd_1
X_3258_ systolic_unit_0.U_10.acc_1\[6\] systolic_unit_0.U_10.acc_0\[6\] net132 VGND
+ VGND VPWR VPWR _1179_ sky130_fd_sc_hd__mux2_2
X_2209_ net217 net260 net212 net257 VGND VGND VPWR VPWR _1908_ sky130_fd_sc_hd__nand4_1
X_3189_ _1069_ _1104_ _1109_ VGND VGND VPWR VPWR _1110_ sky130_fd_sc_hd__nand3_1
XFILLER_26_267 VGND VGND VPWR VPWR sky130_fd_sc_hd__decap_8
XFILLER_41_204 VGND VGND VPWR VPWR sky130_fd_sc_hd__decap_8
XFILLER_53_15 VPWR VGND VPWR VGND sky130_ef_sc_hd__decap_12
XTAP_TAPCELL_ROW_52_700 VGND VPWR sky130_fd_sc_hd__tapvpwrvgnd_1
XFILLER_41_237 VGND VGND VPWR VPWR sky130_fd_sc_hd__decap_4
XFILLER_1_300 VGND VGND VPWR VPWR sky130_fd_sc_hd__decap_8
XFILLER_1_333 VGND VGND VPWR VPWR sky130_fd_sc_hd__decap_3
XFILLER_1_388 VGND VGND VPWR VPWR sky130_fd_sc_hd__decap_4
XFILLER_64_307 VGND VGND VPWR VPWR sky130_fd_sc_hd__fill_1
XFILLER_91_137 VPWR VGND VPWR VGND sky130_ef_sc_hd__decap_12
XFILLER_17_223 VGND VGND VPWR VPWR sky130_fd_sc_hd__fill_1
XFILLER_72_373 VGND VGND VPWR VPWR sky130_fd_sc_hd__fill_2
XFILLER_17_267 VPWR VGND VPWR VGND sky130_ef_sc_hd__decap_12
Xclkbuf_2_0__f_clk clknet_0_clk VGND VGND VPWR VPWR clknet_2_0__leaf_clk sky130_fd_sc_hd__clkbuf_16
XFILLER_13_473 VPWR VGND VPWR VGND sky130_ef_sc_hd__decap_12
X_2560_ _0541_ _0544_ _0539_ VGND VGND VPWR VPWR _0545_ sky130_fd_sc_hd__a21o_1
X_2491_ _0472_ _0475_ VGND VGND VPWR VPWR _0476_ sky130_fd_sc_hd__nand2_1
X_4230_ net239 VGND VGND VPWR VPWR _0211_ sky130_fd_sc_hd__inv_2
XFILLER_4_53 VPWR VGND VPWR VGND sky130_ef_sc_hd__decap_12
X_4161_ net230 VGND VGND VPWR VPWR _0142_ sky130_fd_sc_hd__inv_2
XFILLER_4_97 VPWR VGND VPWR VGND sky130_ef_sc_hd__decap_12
X_3112_ net157 net101 _1019_ VGND VGND VPWR VPWR _1033_ sky130_fd_sc_hd__a21oi_1
X_4092_ net245 VGND VGND VPWR VPWR _0073_ sky130_fd_sc_hd__inv_2
XFILLER_67_167 VGND VGND VPWR VPWR sky130_fd_sc_hd__fill_1
X_3043_ net94 _0956_ net78 net398 VGND VGND VPWR VPWR _0333_ sky130_fd_sc_hd__a22o_1
XTAP_TAPCELL_ROW_66_825 VGND VPWR sky130_fd_sc_hd__tapvpwrvgnd_1
XFILLER_51_502 VGND VGND VPWR VPWR sky130_fd_sc_hd__fill_2
XFILLER_51_546 VGND VGND VPWR VPWR sky130_fd_sc_hd__decap_4
X_3945_ _1743_ _1748_ VGND VGND VPWR VPWR _1821_ sky130_fd_sc_hd__xnor2_1
XTAP_TAPCELL_ROW_21_405 VGND VPWR sky130_fd_sc_hd__tapvpwrvgnd_1
X_3876_ _1645_ _1763_ VGND VGND VPWR VPWR _1765_ sky130_fd_sc_hd__nand2_1
X_2827_ _0746_ _0747_ VGND VGND VPWR VPWR _0780_ sky130_fd_sc_hd__xnor2_1
X_2758_ net127 net167 _0639_ VGND VGND VPWR VPWR _0711_ sky130_fd_sc_hd__and3_1
X_4428_ clknet_leaf_16_clk _0385_ _0152_ VGND VGND VPWR VPWR net46 sky130_fd_sc_hd__dfrtp_1
X_2689_ systolic_unit_0.U_01.acc_1\[10\] systolic_unit_0.U_01.acc_0\[10\] net141 VGND
+ VGND VPWR VPWR _0642_ sky130_fd_sc_hd__mux2_1
XFILLER_86_421 VGND VGND VPWR VPWR sky130_fd_sc_hd__decap_6
X_4359_ clknet_leaf_18_clk _0332_ _0083_ VGND VGND VPWR VPWR systolic_unit_0.U_01.acc_1\[11\]
+ sky130_fd_sc_hd__dfrtp_1
XFILLER_48_59 VPWR VGND VPWR VGND sky130_ef_sc_hd__decap_12
XFILLER_64_58 VGND VGND VPWR VPWR sky130_fd_sc_hd__decap_8
XFILLER_81_181 VGND VGND VPWR VPWR sky130_fd_sc_hd__decap_3
Xfanout74 _1827_ VGND VGND VPWR VPWR net74 sky130_fd_sc_hd__clkbuf_4
Xfanout96 _1868_ VGND VGND VPWR VPWR net96 sky130_fd_sc_hd__buf_4
XFILLER_10_421 VPWR VGND VPWR VGND sky130_ef_sc_hd__decap_12
XFILLER_22_292 VPWR VGND VPWR VGND sky130_ef_sc_hd__decap_12
Xfanout85 _0591_ VGND VGND VPWR VPWR net85 sky130_fd_sc_hd__clkbuf_2
XFILLER_6_469 VGND VGND VPWR VPWR sky130_fd_sc_hd__decap_6
XFILLER_89_55 VGND VGND VPWR VPWR sky130_fd_sc_hd__fill_1
XTAP_TAPCELL_ROW_9_285 VGND VPWR sky130_fd_sc_hd__tapvpwrvgnd_1
XFILLER_49_101 VGND VGND VPWR VPWR sky130_fd_sc_hd__fill_1
XFILLER_92_457 VPWR VGND VPWR VGND sky130_ef_sc_hd__decap_12
XFILLER_33_502 VGND VGND VPWR VPWR sky130_fd_sc_hd__fill_2
XFILLER_33_513 VPWR VGND VPWR VGND sky130_ef_sc_hd__decap_12
XFILLER_72_192 VGND VGND VPWR VPWR sky130_fd_sc_hd__decap_4
XTAP_TAPCELL_ROW_71_872 VGND VPWR sky130_fd_sc_hd__tapvpwrvgnd_1
XFILLER_20_229 VPWR VGND VPWR VGND sky130_ef_sc_hd__decap_12
X_3730_ _1615_ _1616_ VGND VGND VPWR VPWR _1619_ sky130_fd_sc_hd__xnor2_1
XFILLER_9_241 VGND VGND VPWR VPWR sky130_fd_sc_hd__fill_1
X_3661_ _1548_ _1549_ _1546_ VGND VGND VPWR VPWR _1550_ sky130_fd_sc_hd__a21oi_1
Xclkload22 clknet_leaf_13_clk VGND VGND VPWR VPWR clkload22/Y sky130_fd_sc_hd__inv_6
Xclkload11 clknet_leaf_24_clk VGND VGND VPWR VPWR clkload11/Y sky130_fd_sc_hd__inv_4
X_3592_ _1479_ _1480_ VGND VGND VPWR VPWR _1481_ sky130_fd_sc_hd__nor2_1
X_2612_ net377 net88 _0584_ net210 VGND VGND VPWR VPWR _0372_ sky130_fd_sc_hd__a22o_1
XFILLER_62_3 VGND VGND VPWR VPWR sky130_fd_sc_hd__fill_1
X_2543_ _2105_ _0525_ _0527_ VGND VGND VPWR VPWR _0528_ sky130_fd_sc_hd__and3_1
X_2474_ _0452_ _0457_ VGND VGND VPWR VPWR _0459_ sky130_fd_sc_hd__or2_1
X_4213_ net240 VGND VGND VPWR VPWR _0194_ sky130_fd_sc_hd__inv_2
XTAP_TAPCELL_ROW_79_950 VGND VPWR sky130_fd_sc_hd__tapvpwrvgnd_1
X_4144_ net247 VGND VGND VPWR VPWR _0125_ sky130_fd_sc_hd__inv_2
XFILLER_18_29 VGND VGND VPWR VPWR sky130_fd_sc_hd__decap_4
XFILLER_28_329 VPWR VGND VPWR VGND sky130_ef_sc_hd__decap_12
XTAP_TAPCELL_ROW_87_1027 VGND VPWR sky130_fd_sc_hd__tapvpwrvgnd_1
X_4075_ net227 VGND VGND VPWR VPWR _0056_ sky130_fd_sc_hd__inv_2
XFILLER_55_137 VGND VGND VPWR VPWR sky130_fd_sc_hd__decap_4
X_3026_ _0892_ _0904_ _0918_ VGND VGND VPWR VPWR _0968_ sky130_fd_sc_hd__and3_1
XFILLER_36_362 VGND VGND VPWR VPWR sky130_fd_sc_hd__fill_2
XFILLER_63_181 VGND VGND VPWR VPWR sky130_fd_sc_hd__fill_1
XFILLER_51_332 VGND VGND VPWR VPWR sky130_fd_sc_hd__decap_4
Xclkload5 clknet_leaf_3_clk VGND VGND VPWR VPWR clkload5/X sky130_fd_sc_hd__clkbuf_8
X_3928_ systolic_unit_0.U_01.drain_0 systolic_unit_0.U_11.acc_0\[7\] net97 VGND VGND
+ VPWR VPWR _1809_ sky130_fd_sc_hd__and3b_1
X_3859_ _1744_ _1747_ VGND VGND VPWR VPWR _1748_ sky130_fd_sc_hd__nand2_1
XFILLER_3_417 VPWR VGND VPWR VGND sky130_ef_sc_hd__decap_12
XFILLER_78_229 VGND VGND VPWR VPWR sky130_fd_sc_hd__decap_8
Xfanout220 net4 VGND VGND VPWR VPWR net220 sky130_fd_sc_hd__buf_2
Xfanout231 net253 VGND VGND VPWR VPWR net231 sky130_fd_sc_hd__buf_4
Xfanout264 net20 VGND VGND VPWR VPWR net264 sky130_fd_sc_hd__clkbuf_4
XTAP_TAPCELL_ROW_6_255 VGND VPWR sky130_fd_sc_hd__tapvpwrvgnd_1
Xfanout242 net253 VGND VGND VPWR VPWR net242 sky130_fd_sc_hd__clkbuf_4
Xfanout253 net38 VGND VGND VPWR VPWR net253 sky130_fd_sc_hd__buf_2
XFILLER_86_251 VGND VGND VPWR VPWR sky130_fd_sc_hd__fill_1
XFILLER_74_424 VGND VGND VPWR VPWR sky130_fd_sc_hd__decap_8
Xfanout275 net1 VGND VGND VPWR VPWR net275 sky130_fd_sc_hd__buf_2
XFILLER_86_295 VGND VGND VPWR VPWR sky130_fd_sc_hd__decap_6
XFILLER_75_57 VGND VGND VPWR VPWR sky130_fd_sc_hd__decap_6
XFILLER_15_502 VGND VGND VPWR VPWR sky130_fd_sc_hd__fill_2
XTAP_TAPCELL_ROW_40_577 VGND VPWR sky130_fd_sc_hd__tapvpwrvgnd_1
XFILLER_69_218 VGND VGND VPWR VPWR sky130_fd_sc_hd__decap_3
X_2190_ systolic_unit_0.U_11.acc_0\[5\] systolic_unit_0.U_11.acc_1\[5\] net144 VGND
+ VGND VPWR VPWR _1895_ sky130_fd_sc_hd__mux2_1
XTAP_TAPCELL_ROW_76_920 VGND VPWR sky130_fd_sc_hd__tapvpwrvgnd_1
XFILLER_92_221 VPWR VGND VPWR VGND sky130_ef_sc_hd__decap_12
XFILLER_77_295 VPWR VGND VPWR VGND sky130_ef_sc_hd__decap_12
XFILLER_18_362 VGND VGND VPWR VPWR sky130_fd_sc_hd__fill_2
XTAP_TAPCELL_ROW_48_655 VGND VPWR sky130_fd_sc_hd__tapvpwrvgnd_1
XFILLER_21_505 VPWR VGND VPWR VGND sky130_ef_sc_hd__decap_12
XTAP_TAPCELL_ROW_31_500 VGND VPWR sky130_fd_sc_hd__tapvpwrvgnd_1
XFILLER_60_195 VGND VGND VPWR VPWR sky130_fd_sc_hd__fill_1
X_3713_ _1598_ _1600_ VGND VGND VPWR VPWR _1602_ sky130_fd_sc_hd__xnor2_1
X_3644_ _1527_ _1528_ VGND VGND VPWR VPWR _1533_ sky130_fd_sc_hd__xnor2_2
X_3575_ _1463_ VGND VGND VPWR VPWR _1464_ sky130_fd_sc_hd__inv_2
X_2526_ systolic_unit_0.U_00.acc_1\[0\] systolic_unit_0.U_00.acc_0\[0\] net210 VGND
+ VGND VPWR VPWR _0511_ sky130_fd_sc_hd__mux2_1
XTAP_TAPCELL_ROW_93_1097 VGND VPWR sky130_fd_sc_hd__tapvpwrvgnd_1
XTAP_TAPCELL_ROW_93_1086 VGND VPWR sky130_fd_sc_hd__tapvpwrvgnd_1
X_2457_ _2129_ _0417_ _0441_ _2101_ VGND VGND VPWR VPWR _0442_ sky130_fd_sc_hd__a211o_1
XFILLER_29_39 VGND VGND VPWR VPWR sky130_fd_sc_hd__decap_8
Xhold28 systolic_unit_0.U_10.acc_0\[12\] VGND VGND VPWR VPWR net303 sky130_fd_sc_hd__dlygate4sd3_1
XFILLER_68_273 VPWR VGND VPWR VGND sky130_ef_sc_hd__decap_12
Xhold39 systolic_unit_0.U_10.acc_1\[11\] VGND VGND VPWR VPWR net314 sky130_fd_sc_hd__dlygate4sd3_1
X_2388_ _2085_ _2086_ VGND VGND VPWR VPWR _2087_ sky130_fd_sc_hd__nor2_1
X_4127_ net234 VGND VGND VPWR VPWR _0108_ sky130_fd_sc_hd__inv_2
XFILLER_83_276 VGND VGND VPWR VPWR sky130_fd_sc_hd__decap_4
XFILLER_71_405 VGND VGND VPWR VPWR sky130_fd_sc_hd__decap_8
X_4058_ net227 VGND VGND VPWR VPWR _0039_ sky130_fd_sc_hd__inv_2
XFILLER_45_38 VGND VGND VPWR VPWR sky130_fd_sc_hd__fill_2
X_3009_ _0775_ _0776_ VGND VGND VPWR VPWR _0958_ sky130_fd_sc_hd__nor2_1
XFILLER_71_449 VGND VGND VPWR VPWR sky130_fd_sc_hd__decap_4
XTAP_TAPCELL_ROW_82_978 VGND VPWR sky130_fd_sc_hd__tapvpwrvgnd_1
XFILLER_24_321 VPWR VGND VPWR VGND sky130_ef_sc_hd__decap_12
XFILLER_24_365 VGND VGND VPWR VPWR sky130_fd_sc_hd__decap_4
XFILLER_61_26 VGND VGND VPWR VPWR sky130_fd_sc_hd__decap_3
XFILLER_3_225 VGND VGND VPWR VPWR sky130_fd_sc_hd__decap_3
XFILLER_79_505 VPWR VGND VPWR VGND sky130_ef_sc_hd__decap_12
XFILLER_10_41 VPWR VGND VPWR VGND sky130_ef_sc_hd__decap_12
XFILLER_10_85 VGND VGND VPWR VPWR sky130_fd_sc_hd__decap_3
XFILLER_59_240 VGND VGND VPWR VPWR sky130_fd_sc_hd__decap_8
XFILLER_59_273 VGND VGND VPWR VPWR sky130_fd_sc_hd__fill_1
XFILLER_74_221 VPWR VGND VPWR VGND sky130_ef_sc_hd__decap_12
XFILLER_74_265 VPWR VGND VPWR VGND sky130_ef_sc_hd__decap_12
XTAP_TAPCELL_ROW_45_625 VGND VPWR sky130_fd_sc_hd__tapvpwrvgnd_1
XFILLER_27_181 VPWR VGND VPWR VGND sky130_ef_sc_hd__decap_12
XFILLER_55_490 VPWR VGND VPWR VGND sky130_ef_sc_hd__decap_12
XFILLER_7_553 VGND VGND VPWR VPWR sky130_fd_sc_hd__fill_1
X_3360_ _1275_ _1279_ _1248_ _1260_ VGND VGND VPWR VPWR _1281_ sky130_fd_sc_hd__o211a_1
X_2311_ net254 net258 net213 net271 VGND VGND VPWR VPWR _2010_ sky130_fd_sc_hd__a22oi_1
X_3291_ _1209_ _1210_ _1208_ VGND VGND VPWR VPWR _1212_ sky130_fd_sc_hd__a21bo_1
X_2242_ _1931_ _1940_ VGND VGND VPWR VPWR _1941_ sky130_fd_sc_hd__and2b_1
XFILLER_25_3 VPWR VGND VPWR VGND sky130_ef_sc_hd__decap_12
X_2173_ net340 _1886_ net92 VGND VGND VPWR VPWR _0399_ sky130_fd_sc_hd__mux2_1
XTAP_TAPCELL_ROW_0_206 VGND VPWR sky130_fd_sc_hd__tapvpwrvgnd_1
XFILLER_65_254 VGND VGND VPWR VPWR sky130_fd_sc_hd__fill_2
XFILLER_80_257 VGND VGND VPWR VPWR sky130_fd_sc_hd__decap_6
XFILLER_53_449 VGND VGND VPWR VPWR sky130_fd_sc_hd__decap_4
XFILLER_61_471 VPWR VGND VPWR VGND sky130_ef_sc_hd__decap_12
X_3627_ _1513_ _1515_ VGND VGND VPWR VPWR _1516_ sky130_fd_sc_hd__or2_1
X_3558_ net182 net192 _1446_ VGND VGND VPWR VPWR _1447_ sky130_fd_sc_hd__and3_1
X_2509_ _0491_ _0493_ VGND VGND VPWR VPWR _0494_ sky130_fd_sc_hd__xnor2_1
XFILLER_76_508 VPWR VGND VPWR VGND sky130_ef_sc_hd__decap_12
X_3489_ systolic_unit_0.U_10.acc_0\[1\] systolic_unit_0.U_00.acc_0\[1\] net207 VGND
+ VGND VPWR VPWR _1396_ sky130_fd_sc_hd__mux2_1
XFILLER_56_15 VGND VGND VPWR VPWR sky130_fd_sc_hd__decap_4
XFILLER_56_26 VGND VGND VPWR VPWR sky130_fd_sc_hd__fill_2
XFILLER_56_221 VPWR VGND VPWR VGND sky130_ef_sc_hd__decap_12
XFILLER_56_265 VGND VGND VPWR VPWR sky130_fd_sc_hd__decap_4
XFILLER_71_213 VGND VGND VPWR VPWR sky130_fd_sc_hd__decap_8
XFILLER_16_118 VGND VGND VPWR VPWR sky130_fd_sc_hd__decap_8
XFILLER_44_449 VGND VGND VPWR VPWR sky130_fd_sc_hd__decap_6
XFILLER_72_36 VGND VGND VPWR VPWR sky130_fd_sc_hd__decap_4
XTAP_TAPCELL_ROW_50_672 VGND VPWR sky130_fd_sc_hd__tapvpwrvgnd_1
XFILLER_4_501 VPWR VGND VPWR VGND sky130_ef_sc_hd__decap_12
XFILLER_21_51 VGND VGND VPWR VPWR sky130_fd_sc_hd__decap_4
XFILLER_4_545 VGND VGND VPWR VPWR sky130_fd_sc_hd__decap_8
XFILLER_79_335 VGND VGND VPWR VPWR sky130_fd_sc_hd__fill_1
XFILLER_75_541 VPWR VGND VPWR VGND sky130_ef_sc_hd__decap_12
XTAP_TAPCELL_ROW_58_750 VGND VPWR sky130_fd_sc_hd__tapvpwrvgnd_1
XFILLER_90_533 VPWR VGND VPWR VGND sky130_ef_sc_hd__decap_12
XFILLER_35_416 VGND VGND VPWR VPWR sky130_fd_sc_hd__decap_6
XFILLER_35_427 VPWR VGND VPWR VGND sky130_ef_sc_hd__decap_12
XFILLER_47_287 VGND VGND VPWR VPWR sky130_fd_sc_hd__fill_1
XFILLER_35_449 VGND VGND VPWR VPWR sky130_fd_sc_hd__decap_8
Xclkbuf_leaf_27_clk clknet_2_1__leaf_clk VGND VGND VPWR VPWR clknet_leaf_27_clk sky130_fd_sc_hd__clkbuf_8
XFILLER_50_419 VGND VGND VPWR VPWR sky130_fd_sc_hd__fill_1
X_2860_ _0811_ _0812_ VGND VGND VPWR VPWR _0813_ sky130_fd_sc_hd__nand2b_1
X_2791_ net131 systolic_unit_0.U_00.out_a\[6\] VGND VGND VPWR VPWR _0744_ sky130_fd_sc_hd__nand2_1
X_4461_ clknet_leaf_32_clk _0410_ _0185_ VGND VGND VPWR VPWR net70 sky130_fd_sc_hd__dfrtp_1
X_3412_ _1252_ _1254_ _1330_ _1194_ VGND VGND VPWR VPWR _1333_ sky130_fd_sc_hd__o211ai_1
X_4392_ clknet_leaf_5_clk _0365_ _0116_ VGND VGND VPWR VPWR systolic_unit_0.U_00.acc_1\[12\]
+ sky130_fd_sc_hd__dfrtp_1
XTAP_TAPCELL_ROW_90_1056 VGND VPWR sky130_fd_sc_hd__tapvpwrvgnd_1
X_3343_ net161 net112 net110 net163 VGND VGND VPWR VPWR _1264_ sky130_fd_sc_hd__a22o_1
X_3274_ _1192_ _1194_ VGND VGND VPWR VPWR _1195_ sky130_fd_sc_hd__nand2_1
XFILLER_85_349 VPWR VGND VPWR VGND sky130_ef_sc_hd__decap_12
X_2225_ _1918_ _1920_ VGND VGND VPWR VPWR _1924_ sky130_fd_sc_hd__xnor2_1
XFILLER_66_530 VGND VGND VPWR VPWR sky130_fd_sc_hd__fill_2
XFILLER_26_29 VPWR VGND VPWR VGND sky130_ef_sc_hd__decap_12
X_2156_ systolic_unit_0.out_acc_0_r1\[6\] systolic_unit_0.out_acc_1_r1\[6\] net143
+ VGND VGND VPWR VPWR _1878_ sky130_fd_sc_hd__mux2_1
XFILLER_93_393 VPWR VGND VPWR VGND sky130_ef_sc_hd__decap_12
XPHY_EDGE_ROW_5_Right_5 VGND VGND VPWR VPWR sky130_fd_sc_hd__decap_3
XFILLER_53_246 VGND VGND VPWR VPWR sky130_fd_sc_hd__fill_2
Xclkbuf_leaf_18_clk clknet_2_3__leaf_clk VGND VGND VPWR VPWR clknet_leaf_18_clk sky130_fd_sc_hd__clkbuf_8
XFILLER_21_110 VGND VGND VPWR VPWR sky130_fd_sc_hd__fill_2
X_2989_ _0698_ _0738_ _0936_ _0937_ _0941_ VGND VGND VPWR VPWR _0942_ sky130_fd_sc_hd__a41o_1
XFILLER_21_165 VGND VGND VPWR VPWR sky130_fd_sc_hd__decap_3
XFILLER_88_121 VPWR VGND VPWR VGND sky130_ef_sc_hd__decap_12
XFILLER_88_165 VPWR VGND VPWR VGND sky130_ef_sc_hd__decap_12
XFILLER_76_338 VPWR VGND VPWR VGND sky130_ef_sc_hd__decap_12
XFILLER_67_69 VGND VGND VPWR VPWR sky130_fd_sc_hd__fill_1
XFILLER_83_57 VPWR VGND VPWR VGND sky130_ef_sc_hd__decap_12
XFILLER_72_533 VPWR VGND VPWR VGND sky130_ef_sc_hd__decap_12
XFILLER_17_449 VPWR VGND VPWR VGND sky130_ef_sc_hd__decap_12
XTAP_TAPCELL_ROW_55_720 VGND VPWR sky130_fd_sc_hd__tapvpwrvgnd_1
XTAP_TAPCELL_ROW_27_455 VGND VPWR sky130_fd_sc_hd__tapvpwrvgnd_1
XFILLER_44_279 VGND VGND VPWR VPWR sky130_fd_sc_hd__decap_6
XFILLER_8_103 VPWR VGND VPWR VGND sky130_ef_sc_hd__decap_12
XFILLER_12_165 VPWR VGND VPWR VGND sky130_ef_sc_hd__decap_12
XTAP_TAPCELL_ROW_10_300 VGND VPWR sky130_fd_sc_hd__tapvpwrvgnd_1
XFILLER_8_169 VGND VGND VPWR VPWR sky130_fd_sc_hd__decap_8
XFILLER_32_72 VPWR VGND VPWR VGND sky130_ef_sc_hd__decap_12
XFILLER_67_305 VGND VGND VPWR VPWR sky130_fd_sc_hd__decap_4
XFILLER_75_360 VGND VGND VPWR VPWR sky130_fd_sc_hd__decap_8
XFILLER_35_202 VPWR VGND VPWR VGND sky130_ef_sc_hd__decap_12
XFILLER_63_511 VPWR VGND VPWR VGND sky130_ef_sc_hd__decap_12
XFILLER_75_393 VPWR VGND VPWR VGND sky130_ef_sc_hd__decap_12
X_3961_ _1867_ _1789_ _1832_ VGND VGND VPWR VPWR _0259_ sky130_fd_sc_hd__a21o_1
X_2912_ _0863_ _0864_ _0860_ VGND VGND VPWR VPWR _0865_ sky130_fd_sc_hd__o21a_1
XFILLER_92_3 VPWR VGND VPWR VGND sky130_ef_sc_hd__decap_12
X_3892_ _1434_ _1780_ VGND VGND VPWR VPWR _1781_ sky130_fd_sc_hd__xnor2_1
XTAP_TAPCELL_ROW_61_778 VGND VPWR sky130_fd_sc_hd__tapvpwrvgnd_1
X_2843_ net177 net120 VGND VGND VPWR VPWR _0796_ sky130_fd_sc_hd__nand2_1
XFILLER_31_485 VGND VGND VPWR VPWR sky130_fd_sc_hd__decap_8
X_2774_ _0725_ _0726_ VGND VGND VPWR VPWR _0727_ sky130_fd_sc_hd__nor2_1
X_4513_ clknet_leaf_25_clk net9 _0237_ VGND VGND VPWR VPWR systolic_unit_0.U_10.in_a\[0\]
+ sky130_fd_sc_hd__dfrtp_1
Xhold103 systolic_unit_0.U_00.acc_1\[12\] VGND VGND VPWR VPWR net378 sky130_fd_sc_hd__dlygate4sd3_1
Xhold125 systolic_unit_0.U_01.acc_0\[14\] VGND VGND VPWR VPWR net400 sky130_fd_sc_hd__dlygate4sd3_1
Xhold114 systolic_unit_0.U_01.acc_1\[3\] VGND VGND VPWR VPWR net389 sky130_fd_sc_hd__dlygate4sd3_1
Xclkbuf_leaf_7_clk clknet_2_2__leaf_clk VGND VGND VPWR VPWR clknet_leaf_7_clk sky130_fd_sc_hd__clkbuf_8
X_4444_ clknet_leaf_29_clk net272 _0168_ VGND VGND VPWR VPWR systolic_unit_0.U_00.out_b\[0\]
+ sky130_fd_sc_hd__dfrtp_1
Xhold147 net52 VGND VGND VPWR VPWR net422 sky130_fd_sc_hd__dlygate4sd3_1
Xhold136 systolic_unit_0.U_01.acc_1\[8\] VGND VGND VPWR VPWR net411 sky130_fd_sc_hd__dlygate4sd3_1
X_4375_ clknet_leaf_17_clk _0348_ _0099_ VGND VGND VPWR VPWR systolic_unit_0.U_01.acc_0\[11\]
+ sky130_fd_sc_hd__dfrtp_1
X_3326_ _1224_ _1225_ _1243_ VGND VGND VPWR VPWR _1247_ sky130_fd_sc_hd__a21o_1
XFILLER_58_305 VGND VGND VPWR VPWR sky130_fd_sc_hd__decap_3
XFILLER_85_113 VPWR VGND VPWR VGND sky130_ef_sc_hd__decap_12
XTAP_TAPCELL_ROW_69_856 VGND VPWR sky130_fd_sc_hd__tapvpwrvgnd_1
X_3257_ net162 net105 net103 net164 VGND VGND VPWR VPWR _1178_ sky130_fd_sc_hd__a22o_1
XFILLER_37_28 VPWR VGND VPWR VGND sky130_ef_sc_hd__decap_12
X_2208_ net217 net260 net212 net257 VGND VGND VPWR VPWR _1907_ sky130_fd_sc_hd__and4_1
X_3188_ _1106_ _1107_ _1105_ VGND VGND VPWR VPWR _1109_ sky130_fd_sc_hd__a21bo_1
XFILLER_54_533 VGND VGND VPWR VPWR sky130_fd_sc_hd__decap_6
X_2139_ net428 _1869_ net90 VGND VGND VPWR VPWR _0416_ sky130_fd_sc_hd__mux2_1
XFILLER_14_419 VGND VGND VPWR VPWR sky130_fd_sc_hd__fill_1
XFILLER_53_27 VPWR VGND VPWR VGND sky130_ef_sc_hd__decap_12
XTAP_TAPCELL_ROW_24_425 VGND VPWR sky130_fd_sc_hd__tapvpwrvgnd_1
XFILLER_1_367 VGND VGND VPWR VPWR sky130_fd_sc_hd__decap_8
XFILLER_76_157 VGND VGND VPWR VPWR sky130_fd_sc_hd__fill_1
XFILLER_49_349 VGND VGND VPWR VPWR sky130_fd_sc_hd__decap_3
XFILLER_91_105 VGND VGND VPWR VPWR sky130_fd_sc_hd__decap_6
XFILLER_64_319 VPWR VGND VPWR VGND sky130_ef_sc_hd__decap_12
XFILLER_91_149 VPWR VGND VPWR VGND sky130_ef_sc_hd__decap_12
XFILLER_17_246 VGND VGND VPWR VPWR sky130_fd_sc_hd__fill_1
XFILLER_57_382 VGND VGND VPWR VPWR sky130_fd_sc_hd__decap_8
XFILLER_57_393 VGND VGND VPWR VPWR sky130_fd_sc_hd__fill_1
XFILLER_17_279 VGND VGND VPWR VPWR sky130_fd_sc_hd__fill_1
XFILLER_13_441 VGND VGND VPWR VPWR sky130_fd_sc_hd__decap_6
XFILLER_13_485 VPWR VGND VPWR VGND sky130_ef_sc_hd__decap_12
X_2490_ _0473_ _0474_ net275 net269 VGND VGND VPWR VPWR _0475_ sky130_fd_sc_hd__and4bb_1
XFILLER_4_183 VGND VGND VPWR VPWR sky130_fd_sc_hd__decap_6
XFILLER_4_65 VPWR VGND VPWR VGND sky130_ef_sc_hd__decap_12
X_4160_ net236 VGND VGND VPWR VPWR _0141_ sky130_fd_sc_hd__inv_2
X_3111_ _1023_ _1024_ VGND VGND VPWR VPWR _1032_ sky130_fd_sc_hd__xor2_1
XFILLER_67_113 VGND VGND VPWR VPWR sky130_fd_sc_hd__decap_8
X_4091_ net245 VGND VGND VPWR VPWR _0072_ sky130_fd_sc_hd__inv_2
X_3042_ net94 _0955_ net77 net402 VGND VGND VPWR VPWR _0334_ sky130_fd_sc_hd__a22o_1
XTAP_TAPCELL_ROW_66_826 VGND VPWR sky130_fd_sc_hd__tapvpwrvgnd_1
XFILLER_36_533 VPWR VGND VPWR VGND sky130_ef_sc_hd__decap_12
XFILLER_51_536 VGND VGND VPWR VPWR sky130_fd_sc_hd__decap_6
XFILLER_63_374 VGND VGND VPWR VPWR sky130_fd_sc_hd__decap_4
X_3944_ net144 _1819_ _1820_ VGND VGND VPWR VPWR _0276_ sky130_fd_sc_hd__a21o_1
X_3875_ _1760_ _1763_ VGND VGND VPWR VPWR _1764_ sky130_fd_sc_hd__nand2b_1
X_2826_ _0754_ _0755_ VGND VGND VPWR VPWR _0779_ sky130_fd_sc_hd__xnor2_1
X_2757_ _0703_ _0709_ VGND VGND VPWR VPWR _0710_ sky130_fd_sc_hd__and2_1
X_2688_ _0638_ _0640_ VGND VGND VPWR VPWR _0641_ sky130_fd_sc_hd__or2_1
XFILLER_2_109 VPWR VGND VPWR VGND sky130_ef_sc_hd__decap_12
X_4427_ clknet_leaf_7_clk net213 _0151_ VGND VGND VPWR VPWR systolic_unit_0.U_00.out_a\[7\]
+ sky130_fd_sc_hd__dfrtp_1
X_4358_ clknet_leaf_15_clk _0331_ _0082_ VGND VGND VPWR VPWR systolic_unit_0.U_01.acc_1\[10\]
+ sky130_fd_sc_hd__dfrtp_1
X_3309_ _1227_ _1228_ _1226_ VGND VGND VPWR VPWR _1230_ sky130_fd_sc_hd__a21bo_1
X_4289_ clknet_leaf_24_clk _0270_ VGND VGND VPWR VPWR row_count\[0\] sky130_fd_sc_hd__dfxtp_1
XFILLER_86_477 VPWR VGND VPWR VGND sky130_ef_sc_hd__decap_12
XFILLER_58_179 VGND VGND VPWR VPWR sky130_fd_sc_hd__decap_8
XFILLER_39_393 VGND VGND VPWR VPWR sky130_fd_sc_hd__decap_3
XFILLER_64_15 VPWR VGND VPWR VGND sky130_ef_sc_hd__decap_12
XTAP_TAPCELL_ROW_37_550 VGND VPWR sky130_fd_sc_hd__tapvpwrvgnd_1
XFILLER_10_433 VPWR VGND VPWR VGND sky130_ef_sc_hd__decap_12
Xfanout97 net98 VGND VGND VPWR VPWR net97 sky130_fd_sc_hd__clkbuf_4
Xfanout75 _1784_ VGND VGND VPWR VPWR net75 sky130_fd_sc_hd__clkbuf_4
XFILLER_10_477 VPWR VGND VPWR VGND sky130_ef_sc_hd__decap_12
XFILLER_77_400 VGND VGND VPWR VPWR sky130_fd_sc_hd__decap_8
XTAP_TAPCELL_ROW_9_286 VGND VPWR sky130_fd_sc_hd__tapvpwrvgnd_1
XFILLER_49_113 VGND VGND VPWR VPWR sky130_fd_sc_hd__fill_2
XFILLER_49_135 VGND VGND VPWR VPWR sky130_fd_sc_hd__decap_6
XFILLER_18_533 VPWR VGND VPWR VGND sky130_ef_sc_hd__decap_12
XFILLER_45_330 VGND VGND VPWR VPWR sky130_fd_sc_hd__decap_3
XFILLER_92_469 VGND VGND VPWR VPWR sky130_fd_sc_hd__decap_6
XFILLER_45_363 VPWR VGND VPWR VGND sky130_ef_sc_hd__decap_12
XFILLER_33_525 VPWR VGND VPWR VGND sky130_ef_sc_hd__decap_12
XFILLER_60_333 VGND VGND VPWR VPWR sky130_fd_sc_hd__fill_1
XFILLER_60_344 VGND VGND VPWR VPWR sky130_fd_sc_hd__decap_3
XTAP_TAPCELL_ROW_71_873 VGND VPWR sky130_fd_sc_hd__tapvpwrvgnd_1
XFILLER_20_219 VGND VGND VPWR VPWR sky130_fd_sc_hd__fill_1
X_3660_ net184 net194 systolic_unit_0.U_10.out_a\[6\] net185 VGND VGND VPWR VPWR _1549_
+ sky130_fd_sc_hd__a22o_1
Xclkload23 clknet_leaf_14_clk VGND VGND VPWR VPWR clkload23/Y sky130_fd_sc_hd__inv_6
X_3591_ net194 net181 net180 net196 VGND VGND VPWR VPWR _1480_ sky130_fd_sc_hd__a22oi_1
Xclkload12 clknet_leaf_26_clk VGND VGND VPWR VPWR clkload12/Y sky130_fd_sc_hd__clkinv_2
X_2611_ _0509_ _0514_ VGND VGND VPWR VPWR _0584_ sky130_fd_sc_hd__xnor2_1
XFILLER_55_3 VGND VGND VPWR VPWR sky130_fd_sc_hd__decap_8
X_2542_ _0442_ _0444_ VGND VGND VPWR VPWR _0527_ sky130_fd_sc_hd__nand2_1
X_4212_ net240 VGND VGND VPWR VPWR _0193_ sky130_fd_sc_hd__inv_2
X_2473_ _0452_ _0457_ VGND VGND VPWR VPWR _0458_ sky130_fd_sc_hd__nand2_1
XTAP_TAPCELL_ROW_79_951 VGND VPWR sky130_fd_sc_hd__tapvpwrvgnd_1
X_4143_ net247 VGND VGND VPWR VPWR _0124_ sky130_fd_sc_hd__inv_2
XFILLER_68_444 VGND VGND VPWR VPWR sky130_fd_sc_hd__fill_1
XFILLER_83_425 VPWR VGND VPWR VGND sky130_ef_sc_hd__decap_12
XFILLER_68_477 VGND VGND VPWR VPWR sky130_fd_sc_hd__fill_1
X_4074_ net227 VGND VGND VPWR VPWR _0055_ sky130_fd_sc_hd__inv_2
XTAP_TAPCELL_ROW_87_1028 VGND VPWR sky130_fd_sc_hd__tapvpwrvgnd_1
X_3025_ net399 net84 _0967_ net141 VGND VGND VPWR VPWR _0342_ sky130_fd_sc_hd__a22o_1
XFILLER_51_311 VGND VGND VPWR VPWR sky130_fd_sc_hd__decap_6
XTAP_TAPCELL_ROW_34_520 VGND VPWR sky130_fd_sc_hd__tapvpwrvgnd_1
X_3927_ _1807_ _1759_ VGND VGND VPWR VPWR _1808_ sky130_fd_sc_hd__and2b_1
Xclkload6 clknet_leaf_5_clk VGND VGND VPWR VPWR clkload6/Y sky130_fd_sc_hd__clkinv_2
X_3858_ _1746_ VGND VGND VPWR VPWR _1747_ sky130_fd_sc_hd__inv_2
X_2809_ _0750_ _0752_ _0751_ VGND VGND VPWR VPWR _0762_ sky130_fd_sc_hd__o21ba_1
X_3789_ net188 net201 _1677_ _1675_ VGND VGND VPWR VPWR _1678_ sky130_fd_sc_hd__a31o_1
XFILLER_3_429 VPWR VGND VPWR VGND sky130_ef_sc_hd__decap_12
Xfanout210 net211 VGND VGND VPWR VPWR net210 sky130_fd_sc_hd__buf_2
Xfanout232 net236 VGND VGND VPWR VPWR net232 sky130_fd_sc_hd__buf_4
XFILLER_59_400 VPWR VGND VPWR VGND sky130_ef_sc_hd__decap_12
Xfanout221 net4 VGND VGND VPWR VPWR net221 sky130_fd_sc_hd__clkbuf_2
Xfanout254 net3 VGND VGND VPWR VPWR net254 sky130_fd_sc_hd__buf_2
XTAP_TAPCELL_ROW_6_256 VGND VPWR sky130_fd_sc_hd__tapvpwrvgnd_1
Xfanout243 net247 VGND VGND VPWR VPWR net243 sky130_fd_sc_hd__buf_4
Xfanout265 net20 VGND VGND VPWR VPWR net265 sky130_fd_sc_hd__clkbuf_2
XFILLER_74_447 VPWR VGND VPWR VGND sky130_ef_sc_hd__decap_12
XFILLER_39_190 VGND VGND VPWR VPWR sky130_fd_sc_hd__fill_1
XFILLER_27_385 VGND VGND VPWR VPWR sky130_fd_sc_hd__fill_1
XFILLER_91_57 VPWR VGND VPWR VGND sky130_ef_sc_hd__decap_12
XTAP_TAPCELL_ROW_40_578 VGND VPWR sky130_fd_sc_hd__tapvpwrvgnd_1
XFILLER_92_233 VPWR VGND VPWR VGND sky130_ef_sc_hd__decap_12
XTAP_TAPCELL_ROW_76_921 VGND VPWR sky130_fd_sc_hd__tapvpwrvgnd_1
XFILLER_1_55 VGND VGND VPWR VPWR sky130_fd_sc_hd__fill_1
XFILLER_37_116 VGND VGND VPWR VPWR sky130_fd_sc_hd__fill_2
XFILLER_37_127 VGND VGND VPWR VPWR sky130_fd_sc_hd__decap_8
XFILLER_18_330 VPWR VGND VPWR VGND sky130_ef_sc_hd__decap_12
XTAP_TAPCELL_ROW_48_656 VGND VPWR sky130_fd_sc_hd__tapvpwrvgnd_1
XFILLER_80_417 VGND VGND VPWR VPWR sky130_fd_sc_hd__decap_3
XFILLER_45_160 VGND VGND VPWR VPWR sky130_fd_sc_hd__fill_1
XFILLER_18_396 VPWR VGND VPWR VGND sky130_ef_sc_hd__decap_12
XFILLER_21_517 VPWR VGND VPWR VGND sky130_ef_sc_hd__decap_12
X_3712_ _1559_ _1598_ _1599_ VGND VGND VPWR VPWR _1601_ sky130_fd_sc_hd__or3_1
X_3643_ _1530_ _1531_ VGND VGND VPWR VPWR _1532_ sky130_fd_sc_hd__nand2_1
X_3574_ _1442_ _1461_ VGND VGND VPWR VPWR _1463_ sky130_fd_sc_hd__xor2_1
X_2525_ _0492_ _0504_ _0505_ VGND VGND VPWR VPWR _0510_ sky130_fd_sc_hd__a21oi_1
XTAP_TAPCELL_ROW_93_1098 VGND VPWR sky130_fd_sc_hd__tapvpwrvgnd_1
XTAP_TAPCELL_ROW_93_1087 VGND VPWR sky130_fd_sc_hd__tapvpwrvgnd_1
X_2456_ _2092_ _2100_ _2099_ VGND VGND VPWR VPWR _0441_ sky130_fd_sc_hd__o21ba_1
Xhold29 systolic_unit_0.U_10.acc_0\[10\] VGND VGND VPWR VPWR net304 sky130_fd_sc_hd__dlygate4sd3_1
Xhold18 systolic_unit_0.U_10.acc_0\[14\] VGND VGND VPWR VPWR net293 sky130_fd_sc_hd__dlygate4sd3_1
XTAP_TAPCELL_ROW_3_226 VGND VPWR sky130_fd_sc_hd__tapvpwrvgnd_1
X_4126_ net229 VGND VGND VPWR VPWR _0107_ sky130_fd_sc_hd__inv_2
X_2387_ net271 net216 net214 net273 VGND VGND VPWR VPWR _2086_ sky130_fd_sc_hd__a22oi_1
XFILLER_68_285 VGND VGND VPWR VPWR sky130_fd_sc_hd__fill_2
X_4057_ net222 VGND VGND VPWR VPWR _0038_ sky130_fd_sc_hd__inv_2
X_3008_ _0736_ _0737_ VGND VGND VPWR VPWR _0957_ sky130_fd_sc_hd__nor2_1
XTAP_TAPCELL_ROW_82_979 VGND VPWR sky130_fd_sc_hd__tapvpwrvgnd_1
XTAP_TAPCELL_ROW_19_380 VGND VPWR sky130_fd_sc_hd__tapvpwrvgnd_1
XFILLER_24_333 VGND VGND VPWR VPWR sky130_fd_sc_hd__fill_1
XFILLER_10_53 VPWR VGND VPWR VGND sky130_ef_sc_hd__decap_12
XFILLER_79_517 VPWR VGND VPWR VGND sky130_ef_sc_hd__decap_12
XFILLER_19_51 VGND VGND VPWR VPWR sky130_fd_sc_hd__decap_4
XFILLER_74_233 VGND VGND VPWR VPWR sky130_fd_sc_hd__decap_3
XFILLER_19_95 VGND VGND VPWR VPWR sky130_fd_sc_hd__fill_1
XFILLER_47_469 VPWR VGND VPWR VGND sky130_ef_sc_hd__decap_12
XFILLER_74_277 VPWR VGND VPWR VGND sky130_ef_sc_hd__decap_12
XTAP_TAPCELL_ROW_45_626 VGND VPWR sky130_fd_sc_hd__tapvpwrvgnd_1
XFILLER_62_417 VGND VGND VPWR VPWR sky130_fd_sc_hd__decap_3
XFILLER_27_193 VGND VGND VPWR VPWR sky130_fd_sc_hd__decap_6
XFILLER_51_60 VGND VGND VPWR VPWR sky130_fd_sc_hd__decap_8
X_2310_ net271 net254 net258 net213 VGND VGND VPWR VPWR _2009_ sky130_fd_sc_hd__and4_1
X_3290_ _1208_ _1209_ _1210_ VGND VGND VPWR VPWR _1211_ sky130_fd_sc_hd__and3_1
XPHY_EDGE_ROW_29_Left_123 VGND VGND VPWR VPWR sky130_fd_sc_hd__decap_3
X_2241_ _1933_ _1938_ VGND VGND VPWR VPWR _1940_ sky130_fd_sc_hd__xnor2_1
XFILLER_18_3 VPWR VGND VPWR VGND sky130_ef_sc_hd__decap_12
X_2172_ systolic_unit_0.U_11.acc_0\[14\] systolic_unit_0.U_11.acc_1\[14\] net148 VGND
+ VGND VPWR VPWR _1886_ sky130_fd_sc_hd__mux2_1
XFILLER_93_553 VGND VGND VPWR VPWR sky130_fd_sc_hd__fill_1
XFILLER_38_458 VPWR VGND VPWR VGND sky130_ef_sc_hd__decap_12
XFILLER_80_269 VPWR VGND VPWR VGND sky130_ef_sc_hd__decap_12
XTAP_TAPCELL_ROW_16_350 VGND VPWR sky130_fd_sc_hd__tapvpwrvgnd_1
XPHY_EDGE_ROW_38_Left_132 VGND VGND VPWR VPWR sky130_fd_sc_hd__decap_3
XFILLER_61_483 VPWR VGND VPWR VGND sky130_ef_sc_hd__decap_12
X_3626_ _1513_ _1514_ net200 net178 VGND VGND VPWR VPWR _1515_ sky130_fd_sc_hd__and4bb_1
XPHY_EDGE_ROW_47_Left_141 VGND VGND VPWR VPWR sky130_fd_sc_hd__decap_3
X_3557_ systolic_unit_0.U_11.acc_1\[11\] systolic_unit_0.U_11.acc_0\[11\] net149 VGND
+ VGND VPWR VPWR _1446_ sky130_fd_sc_hd__mux2_1
X_2508_ systolic_unit_0.U_00.acc_1\[2\] systolic_unit_0.U_00.acc_0\[2\] net210 VGND
+ VGND VPWR VPWR _0493_ sky130_fd_sc_hd__mux2_1
X_3488_ net323 _1356_ _1394_ _1395_ VGND VGND VPWR VPWR _0307_ sky130_fd_sc_hd__a22o_1
X_2439_ net272 net270 net221 net219 VGND VGND VPWR VPWR _0424_ sky130_fd_sc_hd__and4_1
XFILLER_84_531 VGND VGND VPWR VPWR sky130_fd_sc_hd__fill_1
XFILLER_84_553 VGND VGND VPWR VPWR sky130_fd_sc_hd__fill_1
XFILLER_56_233 VPWR VGND VPWR VGND sky130_ef_sc_hd__decap_12
X_4109_ net233 VGND VGND VPWR VPWR _0090_ sky130_fd_sc_hd__inv_2
XFILLER_71_258 VGND VGND VPWR VPWR sky130_fd_sc_hd__decap_8
XFILLER_71_225 VPWR VGND VPWR VGND sky130_ef_sc_hd__decap_12
XFILLER_37_491 VGND VGND VPWR VPWR sky130_fd_sc_hd__fill_1
XPHY_EDGE_ROW_56_Left_150 VGND VGND VPWR VPWR sky130_fd_sc_hd__decap_3
XFILLER_24_152 VPWR VGND VPWR VGND sky130_ef_sc_hd__decap_12
XTAP_TAPCELL_ROW_50_673 VGND VPWR sky130_fd_sc_hd__tapvpwrvgnd_1
XFILLER_4_513 VPWR VGND VPWR VGND sky130_ef_sc_hd__decap_12
XFILLER_87_380 VPWR VGND VPWR VGND sky130_ef_sc_hd__decap_12
XFILLER_75_553 VGND VGND VPWR VPWR sky130_fd_sc_hd__fill_1
XTAP_TAPCELL_ROW_58_751 VGND VPWR sky130_fd_sc_hd__tapvpwrvgnd_1
XFILLER_90_501 VPWR VGND VPWR VGND sky130_ef_sc_hd__decap_12
XFILLER_90_545 VGND VGND VPWR VPWR sky130_fd_sc_hd__decap_8
XFILLER_35_439 VGND VGND VPWR VPWR sky130_fd_sc_hd__decap_8
XFILLER_15_130 VGND VGND VPWR VPWR sky130_fd_sc_hd__decap_3
XFILLER_62_81 VGND VGND VPWR VPWR sky130_fd_sc_hd__decap_3
X_2790_ systolic_unit_0.U_01.acc_1\[6\] systolic_unit_0.U_01.acc_0\[6\] net138 VGND
+ VGND VPWR VPWR _0743_ sky130_fd_sc_hd__mux2_1
XFILLER_11_391 VGND VGND VPWR VPWR sky130_fd_sc_hd__fill_1
X_4460_ clknet_leaf_31_clk _0409_ _0184_ VGND VGND VPWR VPWR net69 sky130_fd_sc_hd__dfrtp_1
X_3411_ _1252_ _1254_ VGND VGND VPWR VPWR _1332_ sky130_fd_sc_hd__or2_1
X_4391_ clknet_leaf_1_clk _0364_ _0115_ VGND VGND VPWR VPWR systolic_unit_0.U_00.acc_1\[11\]
+ sky130_fd_sc_hd__dfrtp_1
X_3342_ net163 net161 net112 net110 VGND VGND VPWR VPWR _1263_ sky130_fd_sc_hd__nand4_1
XTAP_TAPCELL_ROW_90_1057 VGND VPWR sky130_fd_sc_hd__tapvpwrvgnd_1
X_3273_ _1185_ _1187_ _1191_ _1193_ VGND VGND VPWR VPWR _1194_ sky130_fd_sc_hd__a211o_1
X_2224_ _1914_ _1922_ _1912_ VGND VGND VPWR VPWR _1923_ sky130_fd_sc_hd__mux2_1
XFILLER_66_553 VGND VGND VPWR VPWR sky130_fd_sc_hd__fill_1
X_2155_ net329 _1877_ net90 VGND VGND VPWR VPWR _0408_ sky130_fd_sc_hd__mux2_1
XFILLER_26_406 VGND VGND VPWR VPWR sky130_fd_sc_hd__fill_1
XFILLER_53_225 VGND VGND VPWR VPWR sky130_fd_sc_hd__decap_4
X_2988_ _0696_ _0939_ VGND VGND VPWR VPWR _0941_ sky130_fd_sc_hd__or2_1
X_3609_ _1492_ _1493_ VGND VGND VPWR VPWR _1498_ sky130_fd_sc_hd__xor2_1
XFILLER_1_505 VPWR VGND VPWR VGND sky130_ef_sc_hd__decap_12
XFILLER_88_133 VGND VGND VPWR VPWR sky130_fd_sc_hd__decap_6
XFILLER_67_26 VGND VGND VPWR VPWR sky130_fd_sc_hd__fill_2
XFILLER_88_177 VPWR VGND VPWR VGND sky130_ef_sc_hd__decap_12
XFILLER_29_200 VPWR VGND VPWR VGND sky130_ef_sc_hd__decap_12
XFILLER_69_391 VGND VGND VPWR VPWR sky130_fd_sc_hd__fill_1
XFILLER_72_501 VPWR VGND VPWR VGND sky130_ef_sc_hd__decap_12
XFILLER_83_69 VPWR VGND VPWR VGND sky130_ef_sc_hd__decap_12
XFILLER_72_545 VGND VGND VPWR VPWR sky130_fd_sc_hd__decap_8
XTAP_TAPCELL_ROW_55_721 VGND VPWR sky130_fd_sc_hd__tapvpwrvgnd_1
XTAP_TAPCELL_ROW_27_456 VGND VPWR sky130_fd_sc_hd__tapvpwrvgnd_1
XFILLER_44_269 VGND VGND VPWR VPWR sky130_fd_sc_hd__fill_2
XPHY_EDGE_ROW_11_Right_11 VGND VGND VPWR VPWR sky130_fd_sc_hd__decap_3
XFILLER_40_453 VGND VGND VPWR VPWR sky130_fd_sc_hd__fill_2
XFILLER_12_177 VPWR VGND VPWR VGND sky130_ef_sc_hd__decap_12
XTAP_TAPCELL_ROW_10_301 VGND VPWR sky130_fd_sc_hd__tapvpwrvgnd_1
XFILLER_8_148 VGND VGND VPWR VPWR sky130_fd_sc_hd__decap_3
XFILLER_4_321 VPWR VGND VPWR VGND sky130_ef_sc_hd__decap_12
XPHY_EDGE_ROW_20_Right_20 VGND VGND VPWR VPWR sky130_fd_sc_hd__decap_3
XFILLER_82_309 VGND VGND VPWR VPWR sky130_fd_sc_hd__decap_6
XFILLER_48_531 VGND VGND VPWR VPWR sky130_fd_sc_hd__fill_1
XFILLER_57_81 VGND VGND VPWR VPWR sky130_fd_sc_hd__decap_8
XFILLER_35_214 VGND VGND VPWR VPWR sky130_fd_sc_hd__decap_8
XFILLER_35_236 VGND VGND VPWR VPWR sky130_fd_sc_hd__decap_3
XFILLER_63_523 VPWR VGND VPWR VGND sky130_ef_sc_hd__decap_12
XFILLER_23_409 VPWR VGND VPWR VGND sky130_ef_sc_hd__decap_12
X_3960_ systolic_unit_0.U_11.acc_1\[14\] net74 _1830_ systolic_unit_0.U_01.acc_1\[14\]
+ VGND VGND VPWR VPWR _1832_ sky130_fd_sc_hd__a22o_1
X_2911_ _0844_ _0859_ VGND VGND VPWR VPWR _0864_ sky130_fd_sc_hd__xnor2_1
X_3891_ _1424_ _1779_ VGND VGND VPWR VPWR _1780_ sky130_fd_sc_hd__xor2_1
XTAP_TAPCELL_ROW_61_779 VGND VPWR sky130_fd_sc_hd__tapvpwrvgnd_1
XFILLER_85_3 VPWR VGND VPWR VGND sky130_ef_sc_hd__decap_12
X_2842_ _0779_ _0794_ VGND VGND VPWR VPWR _0795_ sky130_fd_sc_hd__or2_1
XFILLER_31_464 VGND VGND VPWR VPWR sky130_fd_sc_hd__fill_1
X_2773_ _0711_ _0713_ _0724_ VGND VGND VPWR VPWR _0726_ sky130_fd_sc_hd__nor3_1
X_4512_ clknet_leaf_14_clk net32 _0236_ VGND VGND VPWR VPWR systolic_unit_0.U_01.in_b\[7\]
+ sky130_fd_sc_hd__dfrtp_1
Xhold115 systolic_unit_0.U_00.acc_1\[10\] VGND VGND VPWR VPWR net390 sky130_fd_sc_hd__dlygate4sd3_1
Xhold104 systolic_unit_0.U_00.acc_0\[10\] VGND VGND VPWR VPWR net379 sky130_fd_sc_hd__dlygate4sd3_1
Xhold126 systolic_unit_0.U_01.acc_1\[15\] VGND VGND VPWR VPWR net401 sky130_fd_sc_hd__dlygate4sd3_1
X_4443_ clknet_leaf_16_clk _0400_ _0167_ VGND VGND VPWR VPWR net63 sky130_fd_sc_hd__dfrtp_1
Xhold137 systolic_unit_0.U_01.acc_0\[15\] VGND VGND VPWR VPWR net412 sky130_fd_sc_hd__dlygate4sd3_1
Xhold148 systolic_unit_0.U_01.acc_1\[6\] VGND VGND VPWR VPWR net423 sky130_fd_sc_hd__dlygate4sd3_1
X_4374_ clknet_leaf_15_clk _0347_ _0098_ VGND VGND VPWR VPWR systolic_unit_0.U_01.acc_0\[10\]
+ sky130_fd_sc_hd__dfrtp_1
X_3325_ _1237_ _1239_ VGND VGND VPWR VPWR _1246_ sky130_fd_sc_hd__nand2_1
XFILLER_85_125 VPWR VGND VPWR VGND sky130_ef_sc_hd__decap_12
X_3256_ net164 net162 net105 net103 VGND VGND VPWR VPWR _1177_ sky130_fd_sc_hd__nand4_1
XTAP_TAPCELL_ROW_69_857 VGND VPWR sky130_fd_sc_hd__tapvpwrvgnd_1
X_2207_ net212 net257 VGND VGND VPWR VPWR _1906_ sky130_fd_sc_hd__nand2_1
XFILLER_85_169 VPWR VGND VPWR VGND sky130_ef_sc_hd__decap_12
X_3187_ _1105_ _1106_ _1107_ VGND VGND VPWR VPWR _1108_ sky130_fd_sc_hd__nand3_1
XFILLER_54_512 VPWR VGND VPWR VGND sky130_ef_sc_hd__decap_12
XFILLER_66_350 VGND VGND VPWR VPWR sky130_fd_sc_hd__decap_3
X_2138_ systolic_unit_0.out_acc_0_r1\[15\] systolic_unit_0.out_acc_1_r1\[15\] net279
+ VGND VGND VPWR VPWR _1869_ sky130_fd_sc_hd__mux2_1
XFILLER_81_364 VPWR VGND VPWR VGND sky130_ef_sc_hd__decap_12
XTAP_TAPCELL_ROW_24_426 VGND VPWR sky130_fd_sc_hd__tapvpwrvgnd_1
XFILLER_1_313 VPWR VGND VPWR VGND sky130_ef_sc_hd__decap_12
XFILLER_45_501 VGND VGND VPWR VPWR sky130_fd_sc_hd__decap_3
XFILLER_64_309 VGND VGND VPWR VPWR sky130_fd_sc_hd__decap_3
XFILLER_27_51 VGND VGND VPWR VPWR sky130_fd_sc_hd__decap_4
XFILLER_40_261 VGND VGND VPWR VPWR sky130_fd_sc_hd__decap_4
XFILLER_13_497 VGND VGND VPWR VPWR sky130_fd_sc_hd__decap_6
XFILLER_57_7 VGND VGND VPWR VPWR sky130_fd_sc_hd__fill_1
XFILLER_4_77 VGND VGND VPWR VPWR sky130_fd_sc_hd__decap_6
X_3110_ _1026_ _1030_ VGND VGND VPWR VPWR _1031_ sky130_fd_sc_hd__nand2_1
X_4090_ net240 VGND VGND VPWR VPWR _0071_ sky130_fd_sc_hd__inv_2
X_3041_ net94 _0953_ net77 net364 VGND VGND VPWR VPWR _0335_ sky130_fd_sc_hd__a22o_1
XFILLER_67_169 VPWR VGND VPWR VGND sky130_ef_sc_hd__decap_12
XTAP_TAPCELL_ROW_66_827 VGND VPWR sky130_fd_sc_hd__tapvpwrvgnd_1
XFILLER_82_139 VGND VGND VPWR VPWR sky130_fd_sc_hd__fill_1
XFILLER_36_545 VGND VGND VPWR VPWR sky130_fd_sc_hd__decap_8
X_3943_ systolic_unit_0.U_01.acc_0\[3\] net75 net82 systolic_unit_0.U_11.acc_0\[3\]
+ VGND VGND VPWR VPWR _1820_ sky130_fd_sc_hd__a22o_1
X_3874_ _1761_ _1762_ VGND VGND VPWR VPWR _1763_ sky130_fd_sc_hd__xor2_1
X_2825_ _0767_ _0769_ VGND VGND VPWR VPWR _0778_ sky130_fd_sc_hd__xnor2_1
X_2756_ net129 systolic_unit_0.U_00.out_a\[6\] _0708_ _0706_ VGND VGND VPWR VPWR _0709_
+ sky130_fd_sc_hd__a31o_1
X_2687_ net123 net166 _0639_ VGND VGND VPWR VPWR _0640_ sky130_fd_sc_hd__and3_1
X_4426_ clknet_leaf_7_clk net215 _0150_ VGND VGND VPWR VPWR systolic_unit_0.U_00.out_a\[6\]
+ sky130_fd_sc_hd__dfrtp_4
XFILLER_86_401 VGND VGND VPWR VPWR sky130_fd_sc_hd__decap_8
X_4357_ clknet_leaf_18_clk _0330_ _0081_ VGND VGND VPWR VPWR systolic_unit_0.U_01.acc_1\[9\]
+ sky130_fd_sc_hd__dfrtp_1
X_3308_ _1228_ _1227_ _1226_ VGND VGND VPWR VPWR _1229_ sky130_fd_sc_hd__and3_1
X_4288_ clknet_leaf_24_clk _0269_ VGND VGND VPWR VPWR net71 sky130_fd_sc_hd__dfxtp_1
XFILLER_86_489 VPWR VGND VPWR VGND sky130_ef_sc_hd__decap_12
X_3239_ _1125_ _1159_ VGND VGND VPWR VPWR _1160_ sky130_fd_sc_hd__and2_1
XFILLER_46_309 VPWR VGND VPWR VGND sky130_ef_sc_hd__decap_12
XFILLER_58_169 VGND VGND VPWR VPWR sky130_fd_sc_hd__fill_1
XFILLER_73_139 VPWR VGND VPWR VGND sky130_ef_sc_hd__decap_12
XFILLER_64_27 VGND VGND VPWR VPWR sky130_fd_sc_hd__fill_1
XTAP_TAPCELL_ROW_37_551 VGND VPWR sky130_fd_sc_hd__tapvpwrvgnd_1
XFILLER_54_342 VGND VGND VPWR VPWR sky130_fd_sc_hd__decap_8
XFILLER_81_150 VPWR VGND VPWR VGND sky130_ef_sc_hd__decap_12
XFILLER_80_15 VGND VGND VPWR VPWR sky130_fd_sc_hd__decap_4
Xfanout76 _1403_ VGND VGND VPWR VPWR net76 sky130_fd_sc_hd__clkbuf_4
Xfanout98 _1867_ VGND VGND VPWR VPWR net98 sky130_fd_sc_hd__buf_2
XFILLER_10_445 VPWR VGND VPWR VGND sky130_ef_sc_hd__decap_12
XFILLER_10_489 VPWR VGND VPWR VGND sky130_ef_sc_hd__decap_12
XFILLER_89_57 VPWR VGND VPWR VGND sky130_ef_sc_hd__decap_12
XFILLER_89_261 VGND VGND VPWR VPWR sky130_fd_sc_hd__decap_8
XFILLER_77_423 VGND VGND VPWR VPWR sky130_fd_sc_hd__decap_8
XTAP_TAPCELL_ROW_9_287 VGND VPWR sky130_fd_sc_hd__tapvpwrvgnd_1
XFILLER_37_309 VGND VGND VPWR VPWR sky130_fd_sc_hd__fill_1
XFILLER_38_83 VGND VGND VPWR VPWR sky130_fd_sc_hd__fill_1
XFILLER_45_320 VGND VGND VPWR VPWR sky130_fd_sc_hd__decap_6
XFILLER_18_545 VGND VGND VPWR VPWR sky130_fd_sc_hd__decap_8
XFILLER_72_161 VGND VGND VPWR VPWR sky130_fd_sc_hd__decap_3
XFILLER_33_537 VPWR VGND VPWR VGND sky130_ef_sc_hd__decap_12
XFILLER_45_375 VGND VGND VPWR VPWR sky130_fd_sc_hd__decap_8
XTAP_TAPCELL_ROW_71_874 VGND VPWR sky130_fd_sc_hd__tapvpwrvgnd_1
Xclkload24 clknet_leaf_15_clk VGND VGND VPWR VPWR clkload24/Y sky130_fd_sc_hd__clkinvlp_4
X_3590_ net196 net194 net181 net180 VGND VGND VPWR VPWR _1479_ sky130_fd_sc_hd__and4_1
Xclkload13 clknet_leaf_27_clk VGND VGND VPWR VPWR clkload13/Y sky130_fd_sc_hd__inv_6
X_2610_ net426 net88 _0583_ net211 VGND VGND VPWR VPWR _0373_ sky130_fd_sc_hd__a22o_1
X_2541_ _2105_ _0525_ VGND VGND VPWR VPWR _0526_ sky130_fd_sc_hd__nand2_1
XPHY_EDGE_ROW_10_Left_104 VGND VGND VPWR VPWR sky130_fd_sc_hd__decap_3
X_2472_ systolic_unit_0.U_00.acc_1\[4\] systolic_unit_0.U_00.acc_0\[4\] net211 VGND
+ VGND VPWR VPWR _0457_ sky130_fd_sc_hd__mux2_1
X_4211_ net242 VGND VGND VPWR VPWR _0192_ sky130_fd_sc_hd__inv_2
XFILLER_48_3 VGND VGND VPWR VPWR sky130_fd_sc_hd__decap_6
XTAP_TAPCELL_ROW_79_952 VGND VPWR sky130_fd_sc_hd__tapvpwrvgnd_1
X_4142_ net241 VGND VGND VPWR VPWR _0123_ sky130_fd_sc_hd__inv_2
XFILLER_28_309 VGND VGND VPWR VPWR sky130_fd_sc_hd__decap_4
X_4073_ net224 VGND VGND VPWR VPWR _0054_ sky130_fd_sc_hd__inv_2
XTAP_TAPCELL_ROW_87_1029 VGND VPWR sky130_fd_sc_hd__tapvpwrvgnd_1
XFILLER_83_437 VGND VGND VPWR VPWR sky130_fd_sc_hd__decap_8
X_3024_ _0919_ _0920_ VGND VGND VPWR VPWR _0967_ sky130_fd_sc_hd__xnor2_1
XFILLER_83_459 VGND VGND VPWR VPWR sky130_fd_sc_hd__fill_1
XTAP_TAPCELL_ROW_34_521 VGND VPWR sky130_fd_sc_hd__tapvpwrvgnd_1
XFILLER_51_356 VGND VGND VPWR VPWR sky130_fd_sc_hd__decap_6
XFILLER_63_194 VPWR VGND VPWR VGND sky130_ef_sc_hd__decap_12
X_3926_ _1753_ _1756_ _1755_ _1702_ VGND VGND VPWR VPWR _1807_ sky130_fd_sc_hd__o211a_1
X_3857_ net190 net204 _1745_ VGND VGND VPWR VPWR _1746_ sky130_fd_sc_hd__nand3_1
Xclkload7 clknet_leaf_6_clk VGND VGND VPWR VPWR clkload7/Y sky130_fd_sc_hd__inv_6
X_2808_ _0758_ _0760_ VGND VGND VPWR VPWR _0761_ sky130_fd_sc_hd__nor2_1
X_3788_ _1673_ _1674_ VGND VGND VPWR VPWR _1677_ sky130_fd_sc_hd__xnor2_2
X_2739_ _0690_ _0691_ VGND VGND VPWR VPWR _0692_ sky130_fd_sc_hd__nand2_1
Xfanout200 systolic_unit_0.U_10.out_a\[2\] VGND VGND VPWR VPWR net200 sky130_fd_sc_hd__buf_2
Xfanout222 net224 VGND VGND VPWR VPWR net222 sky130_fd_sc_hd__buf_4
Xfanout211 switch_r1 VGND VGND VPWR VPWR net211 sky130_fd_sc_hd__clkbuf_4
X_4409_ clknet_leaf_5_clk _0374_ _0133_ VGND VGND VPWR VPWR systolic_unit_0.U_00.acc_0\[5\]
+ sky130_fd_sc_hd__dfrtp_1
XFILLER_59_412 VPWR VGND VPWR VGND sky130_ef_sc_hd__decap_12
XTAP_TAPCELL_ROW_6_257 VGND VPWR sky130_fd_sc_hd__tapvpwrvgnd_1
Xfanout233 net236 VGND VGND VPWR VPWR net233 sky130_fd_sc_hd__buf_4
Xfanout244 net247 VGND VGND VPWR VPWR net244 sky130_fd_sc_hd__clkbuf_4
Xfanout255 net3 VGND VGND VPWR VPWR net255 sky130_fd_sc_hd__dlymetal6s2s_1
XFILLER_86_253 VGND VGND VPWR VPWR sky130_fd_sc_hd__decap_8
Xfanout266 net267 VGND VGND VPWR VPWR net266 sky130_fd_sc_hd__buf_2
XFILLER_46_139 VGND VGND VPWR VPWR sky130_fd_sc_hd__fill_1
XFILLER_74_459 VGND VGND VPWR VPWR sky130_fd_sc_hd__fill_2
XFILLER_27_353 VGND VGND VPWR VPWR sky130_fd_sc_hd__fill_1
XFILLER_42_334 VGND VGND VPWR VPWR sky130_fd_sc_hd__decap_3
XFILLER_91_69 VPWR VGND VPWR VGND sky130_ef_sc_hd__decap_12
XFILLER_42_378 VGND VGND VPWR VPWR sky130_fd_sc_hd__decap_4
XFILLER_24_85 VGND VGND VPWR VPWR sky130_fd_sc_hd__fill_2
XFILLER_10_253 VPWR VGND VPWR VGND sky130_ef_sc_hd__decap_12
XFILLER_10_220 VPWR VGND VPWR VGND sky130_ef_sc_hd__decap_12
XTAP_TAPCELL_ROW_40_579 VGND VPWR sky130_fd_sc_hd__tapvpwrvgnd_1
XFILLER_77_253 VGND VGND VPWR VPWR sky130_fd_sc_hd__decap_6
XFILLER_49_93 VGND VGND VPWR VPWR sky130_fd_sc_hd__decap_8
XTAP_TAPCELL_ROW_76_922 VGND VPWR sky130_fd_sc_hd__tapvpwrvgnd_1
XFILLER_92_245 VGND VGND VPWR VPWR sky130_fd_sc_hd__decap_6
XFILLER_18_320 VGND VGND VPWR VPWR sky130_fd_sc_hd__fill_2
XFILLER_18_342 VPWR VGND VPWR VGND sky130_ef_sc_hd__decap_12
XTAP_TAPCELL_ROW_48_657 VGND VPWR sky130_fd_sc_hd__tapvpwrvgnd_1
XFILLER_52_109 VGND VGND VPWR VPWR sky130_fd_sc_hd__decap_8
XFILLER_65_81 VPWR VGND VPWR VGND sky130_ef_sc_hd__decap_12
XFILLER_60_120 VPWR VGND VPWR VGND sky130_ef_sc_hd__decap_12
XFILLER_33_367 VGND VGND VPWR VPWR sky130_fd_sc_hd__fill_1
XFILLER_21_529 VPWR VGND VPWR VGND sky130_ef_sc_hd__decap_12
XFILLER_33_389 VGND VGND VPWR VPWR sky130_fd_sc_hd__decap_3
XFILLER_60_197 VGND VGND VPWR VPWR sky130_fd_sc_hd__decap_8
X_3711_ _1559_ _1599_ VGND VGND VPWR VPWR _1600_ sky130_fd_sc_hd__nor2_1
X_3642_ _1498_ _1525_ _1529_ VGND VGND VPWR VPWR _1531_ sky130_fd_sc_hd__nand3_1
X_3573_ _1442_ _1461_ VGND VGND VPWR VPWR _1462_ sky130_fd_sc_hd__nand2_1
XPHY_EDGE_ROW_49_Right_49 VGND VGND VPWR VPWR sky130_fd_sc_hd__decap_3
X_2524_ _0507_ _0508_ VGND VGND VPWR VPWR _0509_ sky130_fd_sc_hd__xnor2_1
XTAP_TAPCELL_ROW_93_1099 VGND VPWR sky130_fd_sc_hd__tapvpwrvgnd_1
XTAP_TAPCELL_ROW_93_1088 VGND VPWR sky130_fd_sc_hd__tapvpwrvgnd_1
X_2455_ _2109_ _2114_ _2112_ VGND VGND VPWR VPWR _0440_ sky130_fd_sc_hd__o21ai_1
Xhold19 systolic_unit_0.U_10.acc_0\[1\] VGND VGND VPWR VPWR net294 sky130_fd_sc_hd__dlygate4sd3_1
X_2386_ net273 net271 net216 net214 VGND VGND VPWR VPWR _2085_ sky130_fd_sc_hd__and4_1
XFILLER_68_253 VPWR VGND VPWR VGND sky130_ef_sc_hd__decap_12
X_4125_ net234 VGND VGND VPWR VPWR _0106_ sky130_fd_sc_hd__inv_2
XFILLER_83_223 VGND VGND VPWR VPWR sky130_fd_sc_hd__fill_1
XTAP_TAPCELL_ROW_3_227 VGND VPWR sky130_fd_sc_hd__tapvpwrvgnd_1
XFILLER_28_106 VGND VGND VPWR VPWR sky130_fd_sc_hd__decap_4
XFILLER_28_117 VGND VGND VPWR VPWR sky130_fd_sc_hd__decap_8
XFILLER_28_139 VGND VGND VPWR VPWR sky130_fd_sc_hd__fill_1
XFILLER_56_415 VGND VGND VPWR VPWR sky130_fd_sc_hd__decap_4
XFILLER_83_245 VGND VGND VPWR VPWR sky130_fd_sc_hd__decap_3
X_4056_ net230 VGND VGND VPWR VPWR _0037_ sky130_fd_sc_hd__inv_2
XPHY_EDGE_ROW_58_Right_58 VGND VGND VPWR VPWR sky130_fd_sc_hd__decap_3
X_3007_ net421 net85 _0956_ net139 VGND VGND VPWR VPWR _0349_ sky130_fd_sc_hd__a22o_1
XFILLER_36_161 VGND VGND VPWR VPWR sky130_fd_sc_hd__fill_1
XTAP_TAPCELL_ROW_19_381 VGND VPWR sky130_fd_sc_hd__tapvpwrvgnd_1
XFILLER_51_164 VGND VGND VPWR VPWR sky130_fd_sc_hd__decap_4
XFILLER_61_39 VGND VGND VPWR VPWR sky130_fd_sc_hd__decap_8
X_3909_ _1774_ _1794_ VGND VGND VPWR VPWR _1795_ sky130_fd_sc_hd__and2_1
XPHY_EDGE_ROW_67_Right_67 VGND VGND VPWR VPWR sky130_fd_sc_hd__decap_3
XFILLER_79_529 VPWR VGND VPWR VGND sky130_ef_sc_hd__decap_12
XFILLER_10_65 VGND VGND VPWR VPWR sky130_fd_sc_hd__fill_1
XPHY_EDGE_ROW_76_Right_76 VGND VGND VPWR VPWR sky130_fd_sc_hd__decap_3
XFILLER_19_106 VGND VGND VPWR VPWR sky130_fd_sc_hd__decap_6
XFILLER_74_289 VPWR VGND VPWR VGND sky130_ef_sc_hd__decap_12
XTAP_TAPCELL_ROW_45_627 VGND VPWR sky130_fd_sc_hd__tapvpwrvgnd_1
XFILLER_15_334 VGND VGND VPWR VPWR sky130_fd_sc_hd__fill_2
XFILLER_15_389 VGND VGND VPWR VPWR sky130_fd_sc_hd__decap_3
XFILLER_42_175 VGND VGND VPWR VPWR sky130_fd_sc_hd__decap_4
XPHY_EDGE_ROW_85_Right_85 VGND VGND VPWR VPWR sky130_fd_sc_hd__decap_3
X_2240_ _1911_ _1932_ _1938_ VGND VGND VPWR VPWR _1939_ sky130_fd_sc_hd__or3_1
XFILLER_38_404 VPWR VGND VPWR VGND sky130_ef_sc_hd__decap_12
X_2171_ net343 _1885_ net91 VGND VGND VPWR VPWR _0400_ sky130_fd_sc_hd__mux2_1
XFILLER_46_470 VGND VGND VPWR VPWR sky130_fd_sc_hd__decap_6
XTAP_TAPCELL_ROW_16_351 VGND VPWR sky130_fd_sc_hd__tapvpwrvgnd_1
XFILLER_61_495 VGND VGND VPWR VPWR sky130_fd_sc_hd__decap_8
X_3625_ net197 net181 net180 net199 VGND VGND VPWR VPWR _1514_ sky130_fd_sc_hd__a22oi_1
X_3556_ systolic_unit_0.U_01.out_b\[4\] net191 VGND VGND VPWR VPWR _1445_ sky130_fd_sc_hd__nand2_1
X_2507_ net273 net274 net270 net266 VGND VGND VPWR VPWR _0492_ sky130_fd_sc_hd__nand4_1
XFILLER_88_337 VGND VGND VPWR VPWR sky130_fd_sc_hd__fill_2
X_3487_ systolic_unit_0.U_00.acc_0\[2\] net207 net137 VGND VGND VPWR VPWR _1395_ sky130_fd_sc_hd__a21o_1
X_2438_ net270 net221 net219 net272 VGND VGND VPWR VPWR _0423_ sky130_fd_sc_hd__a22oi_1
XFILLER_29_415 VPWR VGND VPWR VGND sky130_ef_sc_hd__decap_12
X_2369_ _2053_ _2065_ _2066_ VGND VGND VPWR VPWR _2068_ sky130_fd_sc_hd__or3_1
XFILLER_56_245 VGND VGND VPWR VPWR sky130_fd_sc_hd__decap_6
X_4108_ net245 VGND VGND VPWR VPWR _0089_ sky130_fd_sc_hd__inv_2
X_4039_ net240 VGND VGND VPWR VPWR _0020_ sky130_fd_sc_hd__inv_2
XFILLER_44_407 VGND VGND VPWR VPWR sky130_fd_sc_hd__fill_1
XFILLER_71_237 VGND VGND VPWR VPWR sky130_fd_sc_hd__fill_1
XFILLER_24_164 VPWR VGND VPWR VGND sky130_ef_sc_hd__decap_12
XTAP_TAPCELL_ROW_50_674 VGND VPWR sky130_fd_sc_hd__tapvpwrvgnd_1
XFILLER_4_525 VGND VGND VPWR VPWR sky130_fd_sc_hd__decap_6
XTAP_TAPCELL_ROW_58_752 VGND VPWR sky130_fd_sc_hd__tapvpwrvgnd_1
XFILLER_90_513 VPWR VGND VPWR VGND sky130_ef_sc_hd__decap_12
XFILLER_47_278 VGND VGND VPWR VPWR sky130_fd_sc_hd__fill_2
Xmax_cap73 _0436_ VGND VGND VPWR VPWR net73 sky130_fd_sc_hd__clkbuf_1
XFILLER_62_248 VGND VGND VPWR VPWR sky130_fd_sc_hd__decap_4
XFILLER_43_440 VGND VGND VPWR VPWR sky130_fd_sc_hd__decap_8
XFILLER_15_186 VPWR VGND VPWR VGND sky130_ef_sc_hd__decap_12
XTAP_TAPCELL_ROW_13_321 VGND VPWR sky130_fd_sc_hd__tapvpwrvgnd_1
XFILLER_7_55 VGND VGND VPWR VPWR sky130_fd_sc_hd__fill_1
X_3410_ _1194_ _1330_ VGND VGND VPWR VPWR _1331_ sky130_fd_sc_hd__and2_1
X_4390_ clknet_leaf_6_clk _0363_ _0114_ VGND VGND VPWR VPWR systolic_unit_0.U_00.acc_1\[10\]
+ sky130_fd_sc_hd__dfrtp_1
X_3341_ _1232_ _1234_ VGND VGND VPWR VPWR _1262_ sky130_fd_sc_hd__xnor2_1
XTAP_TAPCELL_ROW_90_1058 VGND VPWR sky130_fd_sc_hd__tapvpwrvgnd_1
X_3272_ _1154_ _1167_ _1176_ _1190_ VGND VGND VPWR VPWR _1193_ sky130_fd_sc_hd__o211a_1
XFILLER_30_3 VGND VGND VPWR VPWR sky130_fd_sc_hd__decap_8
XFILLER_85_318 VPWR VGND VPWR VGND sky130_ef_sc_hd__decap_12
X_2223_ _1917_ _1921_ VGND VGND VPWR VPWR _1922_ sky130_fd_sc_hd__xnor2_1
XFILLER_66_510 VPWR VGND VPWR VGND sky130_ef_sc_hd__decap_12
X_2154_ systolic_unit_0.out_acc_0_r1\[7\] systolic_unit_0.out_acc_1_r1\[7\] net143
+ VGND VGND VPWR VPWR _1877_ sky130_fd_sc_hd__mux2_1
XFILLER_61_281 VPWR VGND VPWR VGND sky130_ef_sc_hd__decap_12
X_2987_ _0939_ VGND VGND VPWR VPWR _0940_ sky130_fd_sc_hd__inv_2
XFILLER_21_189 VPWR VGND VPWR VGND sky130_ef_sc_hd__decap_12
X_3608_ _1466_ _1490_ _1494_ VGND VGND VPWR VPWR _1497_ sky130_fd_sc_hd__nor3_1
XFILLER_1_517 VPWR VGND VPWR VGND sky130_ef_sc_hd__decap_12
X_3539_ _1423_ _1427_ VGND VGND VPWR VPWR _1428_ sky130_fd_sc_hd__nor2_1
XFILLER_88_189 VGND VGND VPWR VPWR sky130_fd_sc_hd__decap_6
XFILLER_29_212 VGND VGND VPWR VPWR sky130_fd_sc_hd__fill_2
XFILLER_29_245 VGND VGND VPWR VPWR sky130_fd_sc_hd__decap_4
XFILLER_83_15 VPWR VGND VPWR VGND sky130_ef_sc_hd__decap_12
XFILLER_72_513 VPWR VGND VPWR VGND sky130_ef_sc_hd__decap_12
XTAP_TAPCELL_ROW_55_722 VGND VPWR sky130_fd_sc_hd__tapvpwrvgnd_1
XTAP_TAPCELL_ROW_27_457 VGND VPWR sky130_fd_sc_hd__tapvpwrvgnd_1
XFILLER_40_421 VPWR VGND VPWR VGND sky130_ef_sc_hd__decap_12
XFILLER_40_465 VGND VGND VPWR VPWR sky130_fd_sc_hd__decap_8
XFILLER_40_487 VGND VGND VPWR VPWR sky130_fd_sc_hd__decap_8
XFILLER_12_189 VGND VGND VPWR VPWR sky130_fd_sc_hd__decap_3
XFILLER_32_41 VGND VGND VPWR VPWR sky130_fd_sc_hd__fill_1
XFILLER_4_333 VPWR VGND VPWR VGND sky130_ef_sc_hd__decap_12
XFILLER_79_167 VGND VGND VPWR VPWR sky130_fd_sc_hd__fill_1
XFILLER_90_321 VGND VGND VPWR VPWR sky130_fd_sc_hd__decap_4
XFILLER_63_535 VPWR VGND VPWR VGND sky130_ef_sc_hd__decap_12
XFILLER_90_376 VGND VGND VPWR VPWR sky130_fd_sc_hd__fill_1
X_2910_ _0796_ _0861_ VGND VGND VPWR VPWR _0863_ sky130_fd_sc_hd__xnor2_1
XFILLER_43_270 VGND VGND VPWR VPWR sky130_fd_sc_hd__fill_2
X_3890_ systolic_unit_0.U_11.acc_1\[15\] systolic_unit_0.U_11.acc_0\[15\] net147 VGND
+ VGND VPWR VPWR _1779_ sky130_fd_sc_hd__mux2_1
X_2841_ _0792_ _0793_ _0787_ VGND VGND VPWR VPWR _0794_ sky130_fd_sc_hd__a21boi_1
XPHY_EDGE_ROW_75_Left_169 VGND VGND VPWR VPWR sky130_fd_sc_hd__decap_3
X_2772_ _0711_ _0713_ _0724_ VGND VGND VPWR VPWR _0725_ sky130_fd_sc_hd__o21a_1
XFILLER_78_3 VPWR VGND VPWR VGND sky130_ef_sc_hd__decap_12
X_4511_ clknet_leaf_14_clk net31 _0235_ VGND VGND VPWR VPWR systolic_unit_0.U_01.in_b\[6\]
+ sky130_fd_sc_hd__dfrtp_1
X_4442_ clknet_leaf_16_clk _0399_ _0166_ VGND VGND VPWR VPWR net62 sky130_fd_sc_hd__dfrtp_1
Xhold116 systolic_unit_0.U_01.acc_0\[7\] VGND VGND VPWR VPWR net391 sky130_fd_sc_hd__dlygate4sd3_1
Xhold138 systolic_unit_0.U_00.acc_1\[9\] VGND VGND VPWR VPWR net413 sky130_fd_sc_hd__dlygate4sd3_1
Xhold149 systolic_unit_0.U_01.acc_0\[9\] VGND VGND VPWR VPWR net424 sky130_fd_sc_hd__dlygate4sd3_1
Xhold127 systolic_unit_0.U_01.acc_1\[13\] VGND VGND VPWR VPWR net402 sky130_fd_sc_hd__dlygate4sd3_1
X_4373_ clknet_leaf_18_clk _0346_ _0097_ VGND VGND VPWR VPWR systolic_unit_0.U_01.acc_0\[9\]
+ sky130_fd_sc_hd__dfrtp_1
X_3324_ _1224_ _1225_ _1243_ VGND VGND VPWR VPWR _1245_ sky130_fd_sc_hd__nand3_1
XPHY_EDGE_ROW_84_Left_178 VGND VGND VPWR VPWR sky130_fd_sc_hd__decap_3
X_3255_ _1174_ _1175_ _1138_ VGND VGND VPWR VPWR _1176_ sky130_fd_sc_hd__nand3b_2
XFILLER_85_137 VPWR VGND VPWR VGND sky130_ef_sc_hd__decap_12
X_2206_ _1903_ _1904_ VGND VGND VPWR VPWR _1905_ sky130_fd_sc_hd__and2_1
XTAP_TAPCELL_ROW_69_858 VGND VPWR sky130_fd_sc_hd__tapvpwrvgnd_1
XFILLER_37_19 VGND VGND VPWR VPWR sky130_fd_sc_hd__fill_1
XFILLER_39_532 VGND VGND VPWR VPWR sky130_fd_sc_hd__fill_1
X_3186_ net113 net154 net152 net115 VGND VGND VPWR VPWR _1107_ sky130_fd_sc_hd__a22o_1
XFILLER_66_340 VGND VGND VPWR VPWR sky130_fd_sc_hd__decap_3
XFILLER_93_181 VPWR VGND VPWR VGND sky130_ef_sc_hd__decap_12
XFILLER_26_226 VPWR VGND VPWR VGND sky130_ef_sc_hd__decap_12
X_2137_ systolic_unit_0.U_01.drain_1 systolic_unit_0.U_01.drain_0 VGND VGND VPWR VPWR
+ systolic_unit_0.drain_valid sky130_fd_sc_hd__or2_4
XFILLER_54_524 VGND VGND VPWR VPWR sky130_fd_sc_hd__decap_8
XFILLER_81_376 VPWR VGND VPWR VGND sky130_ef_sc_hd__decap_12
XTAP_TAPCELL_ROW_24_427 VGND VPWR sky130_fd_sc_hd__tapvpwrvgnd_1
XPHY_EDGE_ROW_93_Left_187 VGND VGND VPWR VPWR sky130_fd_sc_hd__decap_3
XFILLER_22_421 VGND VGND VPWR VPWR sky130_fd_sc_hd__fill_1
XFILLER_22_432 VPWR VGND VPWR VGND sky130_ef_sc_hd__decap_12
XFILLER_22_498 VPWR VGND VPWR VGND sky130_ef_sc_hd__decap_12
XFILLER_5_119 VGND VGND VPWR VPWR sky130_fd_sc_hd__fill_1
XFILLER_78_15 VGND VGND VPWR VPWR sky130_fd_sc_hd__decap_3
XFILLER_89_432 VGND VGND VPWR VPWR sky130_fd_sc_hd__decap_4
XFILLER_1_325 VGND VGND VPWR VPWR sky130_fd_sc_hd__decap_8
XFILLER_49_307 VGND VGND VPWR VPWR sky130_fd_sc_hd__decap_4
XFILLER_72_321 VGND VGND VPWR VPWR sky130_fd_sc_hd__fill_1
XFILLER_72_365 VGND VGND VPWR VPWR sky130_fd_sc_hd__fill_1
XFILLER_72_398 VGND VGND VPWR VPWR sky130_fd_sc_hd__decap_8
XFILLER_25_281 VGND VGND VPWR VPWR sky130_fd_sc_hd__decap_4
XFILLER_9_447 VGND VGND VPWR VPWR sky130_fd_sc_hd__fill_1
XFILLER_64_9 VGND VGND VPWR VPWR sky130_fd_sc_hd__fill_2
XFILLER_4_130 VGND VGND VPWR VPWR sky130_fd_sc_hd__decap_3
XFILLER_48_362 VGND VGND VPWR VPWR sky130_fd_sc_hd__fill_2
X_3040_ net95 _0951_ net78 net401 VGND VGND VPWR VPWR _0336_ sky130_fd_sc_hd__a22o_1
XTAP_TAPCELL_ROW_66_828 VGND VPWR sky130_fd_sc_hd__tapvpwrvgnd_1
XFILLER_36_513 VPWR VGND VPWR VGND sky130_ef_sc_hd__decap_12
XFILLER_51_505 VPWR VGND VPWR VGND sky130_ef_sc_hd__decap_12
XFILLER_63_365 VGND VGND VPWR VPWR sky130_fd_sc_hd__fill_1
XFILLER_63_387 VGND VGND VPWR VPWR sky130_fd_sc_hd__decap_4
XFILLER_90_195 VGND VGND VPWR VPWR sky130_fd_sc_hd__fill_1
X_3942_ _1750_ _1818_ VGND VGND VPWR VPWR _1819_ sky130_fd_sc_hd__and2_1
X_3873_ _1653_ _1699_ _1698_ VGND VGND VPWR VPWR _1762_ sky130_fd_sc_hd__a21oi_1
X_2824_ _0772_ _0773_ VGND VGND VPWR VPWR _0777_ sky130_fd_sc_hd__xor2_1
X_2755_ _0704_ _0705_ VGND VGND VPWR VPWR _0708_ sky130_fd_sc_hd__xnor2_1
X_2686_ net125 systolic_unit_0.U_00.out_a\[6\] VGND VGND VPWR VPWR _0639_ sky130_fd_sc_hd__and2_1
X_4425_ clknet_leaf_7_clk net217 _0149_ VGND VGND VPWR VPWR systolic_unit_0.U_00.out_a\[5\]
+ sky130_fd_sc_hd__dfrtp_1
X_4356_ clknet_leaf_18_clk _0329_ _0080_ VGND VGND VPWR VPWR systolic_unit_0.U_01.acc_1\[8\]
+ sky130_fd_sc_hd__dfrtp_1
X_3307_ systolic_unit_0.U_10.acc_1\[4\] systolic_unit_0.U_10.acc_0\[4\] net135 VGND
+ VGND VPWR VPWR _1228_ sky130_fd_sc_hd__mux2_4
XFILLER_48_29 VGND VGND VPWR VPWR sky130_fd_sc_hd__decap_3
X_4287_ clknet_leaf_24_clk net363 VGND VGND VPWR VPWR matrix_count\[2\] sky130_fd_sc_hd__dfxtp_1
X_3238_ _1156_ _1158_ VGND VGND VPWR VPWR _1159_ sky130_fd_sc_hd__or2_1
X_3169_ _1061_ _1089_ VGND VGND VPWR VPWR _1090_ sky130_fd_sc_hd__and2b_1
XFILLER_81_162 VGND VGND VPWR VPWR sky130_fd_sc_hd__decap_6
XTAP_TAPCELL_ROW_37_552 VGND VPWR sky130_fd_sc_hd__tapvpwrvgnd_1
XFILLER_10_402 VPWR VGND VPWR VGND sky130_ef_sc_hd__decap_12
XFILLER_22_251 VGND VGND VPWR VPWR sky130_fd_sc_hd__fill_1
Xfanout99 _1866_ VGND VGND VPWR VPWR net99 sky130_fd_sc_hd__clkbuf_4
Xfanout88 _1901_ VGND VGND VPWR VPWR net88 sky130_fd_sc_hd__clkbuf_4
Xfanout77 _0976_ VGND VGND VPWR VPWR net77 sky130_fd_sc_hd__clkbuf_4
XFILLER_10_457 VPWR VGND VPWR VGND sky130_ef_sc_hd__decap_12
XFILLER_89_69 VPWR VGND VPWR VGND sky130_ef_sc_hd__decap_12
XFILLER_8_3 VPWR VGND VPWR VGND sky130_ef_sc_hd__decap_12
XFILLER_1_111 VGND VGND VPWR VPWR sky130_fd_sc_hd__fill_1
XTAP_TAPCELL_ROW_9_288 VGND VPWR sky130_fd_sc_hd__tapvpwrvgnd_1
XFILLER_77_468 VGND VGND VPWR VPWR sky130_fd_sc_hd__fill_1
XFILLER_38_51 VPWR VGND VPWR VGND sky130_ef_sc_hd__decap_12
XFILLER_57_192 VGND VGND VPWR VPWR sky130_fd_sc_hd__fill_1
XFILLER_33_549 VGND VGND VPWR VPWR sky130_fd_sc_hd__decap_4
XFILLER_54_72 VPWR VGND VPWR VGND sky130_ef_sc_hd__decap_12
XTAP_TAPCELL_ROW_71_875 VGND VPWR sky130_fd_sc_hd__tapvpwrvgnd_1
XFILLER_70_93 VGND VGND VPWR VPWR sky130_fd_sc_hd__decap_3
Xclkload14 clknet_leaf_28_clk VGND VGND VPWR VPWR clkload14/Y sky130_fd_sc_hd__clkinv_4
Xclkload25 clknet_leaf_17_clk VGND VGND VPWR VPWR clkload25/Y sky130_fd_sc_hd__clkinv_4
X_2540_ _2102_ _2104_ _2103_ VGND VGND VPWR VPWR _0525_ sky130_fd_sc_hd__a21o_1
XFILLER_5_461 VPWR VGND VPWR VGND sky130_ef_sc_hd__decap_12
X_2471_ _0427_ _0451_ net86 VGND VGND VPWR VPWR _0456_ sky130_fd_sc_hd__nand3_2
X_4210_ net234 VGND VGND VPWR VPWR _0191_ sky130_fd_sc_hd__inv_2
XTAP_TAPCELL_ROW_79_953 VGND VPWR sky130_fd_sc_hd__tapvpwrvgnd_1
X_4141_ net248 VGND VGND VPWR VPWR _0122_ sky130_fd_sc_hd__inv_2
XFILLER_68_468 VGND VGND VPWR VPWR sky130_fd_sc_hd__fill_1
X_4072_ net230 VGND VGND VPWR VPWR _0053_ sky130_fd_sc_hd__inv_2
XFILLER_83_449 VGND VGND VPWR VPWR sky130_fd_sc_hd__decap_6
X_3023_ systolic_unit_0.U_01.acc_0\[6\] net84 _0966_ net138 VGND VGND VPWR VPWR _0343_
+ sky130_fd_sc_hd__a22o_1
XFILLER_36_387 VGND VGND VPWR VPWR sky130_fd_sc_hd__decap_4
XTAP_TAPCELL_ROW_34_522 VGND VPWR sky130_fd_sc_hd__tapvpwrvgnd_1
X_3925_ net150 _1805_ _1806_ VGND VGND VPWR VPWR _0281_ sky130_fd_sc_hd__a21o_1
Xclkload8 clknet_leaf_31_clk VGND VGND VPWR VPWR clkload8/Y sky130_fd_sc_hd__bufinv_16
X_3856_ systolic_unit_0.U_11.acc_1\[0\] systolic_unit_0.U_11.acc_0\[0\] net147 VGND
+ VGND VPWR VPWR _1745_ sky130_fd_sc_hd__mux2_1
X_2807_ _0758_ _0759_ net177 net118 VGND VGND VPWR VPWR _0760_ sky130_fd_sc_hd__and4bb_1
X_3787_ net188 net201 VGND VGND VPWR VPWR _1676_ sky130_fd_sc_hd__nand2_1
X_2738_ _0667_ _0679_ VGND VGND VPWR VPWR _0691_ sky130_fd_sc_hd__xor2_1
X_2669_ net121 systolic_unit_0.U_00.out_a\[6\] net119 net167 VGND VGND VPWR VPWR _0622_
+ sky130_fd_sc_hd__a22oi_1
X_4408_ clknet_leaf_4_clk _0373_ _0132_ VGND VGND VPWR VPWR systolic_unit_0.U_00.acc_0\[4\]
+ sky130_fd_sc_hd__dfrtp_1
Xfanout212 net213 VGND VGND VPWR VPWR net212 sky130_fd_sc_hd__buf_2
Xfanout201 systolic_unit_0.U_10.out_a\[2\] VGND VGND VPWR VPWR net201 sky130_fd_sc_hd__dlymetal6s2s_1
Xfanout223 net224 VGND VGND VPWR VPWR net223 sky130_fd_sc_hd__buf_4
XFILLER_86_221 VPWR VGND VPWR VGND sky130_ef_sc_hd__decap_12
Xfanout256 net24 VGND VGND VPWR VPWR net256 sky130_fd_sc_hd__buf_2
XTAP_TAPCELL_ROW_6_258 VGND VPWR sky130_fd_sc_hd__tapvpwrvgnd_1
X_4339_ clknet_leaf_3_clk _0320_ _0063_ VGND VGND VPWR VPWR systolic_unit_0.U_10.acc_0\[15\]
+ sky130_fd_sc_hd__dfrtp_1
Xfanout245 net246 VGND VGND VPWR VPWR net245 sky130_fd_sc_hd__buf_4
Xfanout234 net236 VGND VGND VPWR VPWR net234 sky130_fd_sc_hd__clkbuf_4
XFILLER_74_405 VGND VGND VPWR VPWR sky130_fd_sc_hd__fill_1
Xfanout267 net2 VGND VGND VPWR VPWR net267 sky130_fd_sc_hd__buf_2
XFILLER_46_129 VGND VGND VPWR VPWR sky130_fd_sc_hd__fill_1
XFILLER_91_15 VPWR VGND VPWR VGND sky130_ef_sc_hd__decap_12
XFILLER_15_505 VPWR VGND VPWR VGND sky130_ef_sc_hd__decap_12
XFILLER_42_324 VGND VGND VPWR VPWR sky130_fd_sc_hd__decap_4
XFILLER_54_184 VGND VGND VPWR VPWR sky130_fd_sc_hd__decap_3
XFILLER_54_195 VGND VGND VPWR VPWR sky130_fd_sc_hd__fill_1
XFILLER_10_232 VPWR VGND VPWR VGND sky130_ef_sc_hd__decap_12
XFILLER_10_265 VPWR VGND VPWR VGND sky130_ef_sc_hd__decap_12
XFILLER_6_236 VGND VGND VPWR VPWR sky130_fd_sc_hd__decap_6
XFILLER_40_85 VGND VGND VPWR VPWR sky130_fd_sc_hd__decap_6
XFILLER_2_475 VGND VGND VPWR VPWR sky130_fd_sc_hd__fill_1
XFILLER_77_276 VGND VGND VPWR VPWR sky130_fd_sc_hd__decap_4
XTAP_TAPCELL_ROW_76_923 VGND VPWR sky130_fd_sc_hd__tapvpwrvgnd_1
XFILLER_1_57 VPWR VGND VPWR VGND sky130_ef_sc_hd__decap_12
XTAP_TAPCELL_ROW_48_658 VGND VPWR sky130_fd_sc_hd__tapvpwrvgnd_1
XFILLER_18_354 VGND VGND VPWR VPWR sky130_fd_sc_hd__decap_8
XFILLER_18_365 VGND VGND VPWR VPWR sky130_fd_sc_hd__fill_1
XFILLER_65_93 VGND VGND VPWR VPWR sky130_fd_sc_hd__decap_8
XFILLER_60_132 VGND VGND VPWR VPWR sky130_fd_sc_hd__decap_4
XFILLER_81_81 VPWR VGND VPWR VGND sky130_ef_sc_hd__decap_12
X_3710_ net202 net178 _1558_ VGND VGND VPWR VPWR _1599_ sky130_fd_sc_hd__a21oi_1
XFILLER_41_390 VGND VGND VPWR VPWR sky130_fd_sc_hd__fill_2
X_3641_ _1525_ _1529_ _1498_ VGND VGND VPWR VPWR _1530_ sky130_fd_sc_hd__a21o_1
X_3572_ _1444_ _1458_ _1460_ VGND VGND VPWR VPWR _1461_ sky130_fd_sc_hd__a21bo_1
X_2523_ _0490_ _0497_ VGND VGND VPWR VPWR _0508_ sky130_fd_sc_hd__xor2_1
XTAP_TAPCELL_ROW_93_1089 VGND VPWR sky130_fd_sc_hd__tapvpwrvgnd_1
X_2454_ _0432_ _0437_ _0438_ VGND VGND VPWR VPWR _0439_ sky130_fd_sc_hd__nor3_1
XFILLER_68_221 VPWR VGND VPWR VGND sky130_ef_sc_hd__decap_12
X_2385_ net275 net259 VGND VGND VPWR VPWR _2084_ sky130_fd_sc_hd__nand2_1
XFILLER_68_265 VGND VGND VPWR VPWR sky130_fd_sc_hd__decap_4
X_4124_ net233 VGND VGND VPWR VPWR _0105_ sky130_fd_sc_hd__inv_2
XTAP_TAPCELL_ROW_3_228 VGND VPWR sky130_fd_sc_hd__tapvpwrvgnd_1
Xinput1 D_a_00[0] VGND VGND VPWR VPWR net1 sky130_fd_sc_hd__clkbuf_1
X_4055_ net228 VGND VGND VPWR VPWR _0036_ sky130_fd_sc_hd__inv_2
XFILLER_49_490 VGND VGND VPWR VPWR sky130_fd_sc_hd__fill_2
X_3006_ _0698_ _0938_ VGND VGND VPWR VPWR _0956_ sky130_fd_sc_hd__xor2_1
XFILLER_71_419 VGND VGND VPWR VPWR sky130_fd_sc_hd__decap_4
XTAP_TAPCELL_ROW_19_382 VGND VPWR sky130_fd_sc_hd__tapvpwrvgnd_1
XFILLER_36_184 VPWR VGND VPWR VGND sky130_ef_sc_hd__decap_12
XFILLER_51_110 VGND VGND VPWR VPWR sky130_fd_sc_hd__fill_2
XFILLER_24_379 VPWR VGND VPWR VGND sky130_ef_sc_hd__decap_12
XFILLER_51_198 VGND VGND VPWR VPWR sky130_fd_sc_hd__decap_3
XFILLER_20_530 VGND VGND VPWR VPWR sky130_fd_sc_hd__fill_2
X_3908_ _1532_ _1770_ _1771_ _1773_ VGND VGND VPWR VPWR _1794_ sky130_fd_sc_hd__nand4_1
X_3839_ net204 net188 _1727_ _1724_ VGND VGND VPWR VPWR _1728_ sky130_fd_sc_hd__a31o_1
XFILLER_86_15 VPWR VGND VPWR VGND sky130_ef_sc_hd__decap_12
XFILLER_87_541 VPWR VGND VPWR VGND sky130_ef_sc_hd__decap_12
XFILLER_47_405 VGND VGND VPWR VPWR sky130_fd_sc_hd__decap_4
XFILLER_27_140 VGND VGND VPWR VPWR sky130_fd_sc_hd__decap_8
XTAP_TAPCELL_ROW_45_628 VGND VPWR sky130_fd_sc_hd__tapvpwrvgnd_1
XFILLER_70_463 VGND VGND VPWR VPWR sky130_fd_sc_hd__decap_4
XFILLER_42_154 VGND VGND VPWR VPWR sky130_fd_sc_hd__fill_1
XTAP_TAPCELL_ROW_81_970 VGND VPWR sky130_fd_sc_hd__tapvpwrvgnd_1
XFILLER_70_474 VGND VGND VPWR VPWR sky130_fd_sc_hd__fill_2
XFILLER_11_541 VPWR VGND VPWR VGND sky130_ef_sc_hd__decap_12
XFILLER_23_390 VGND VGND VPWR VPWR sky130_fd_sc_hd__fill_2
XFILLER_30_349 VGND VGND VPWR VPWR sky130_fd_sc_hd__fill_1
XFILLER_51_95 VGND VGND VPWR VPWR sky130_fd_sc_hd__decap_8
XFILLER_2_250 VGND VGND VPWR VPWR sky130_fd_sc_hd__fill_2
XFILLER_38_416 VGND VGND VPWR VPWR sky130_fd_sc_hd__decap_4
X_2170_ systolic_unit_0.U_11.acc_0\[15\] systolic_unit_0.U_11.acc_1\[15\] net148 VGND
+ VGND VPWR VPWR _1885_ sky130_fd_sc_hd__mux2_1
XFILLER_93_533 VPWR VGND VPWR VGND sky130_ef_sc_hd__decap_12
XFILLER_65_235 VGND VGND VPWR VPWR sky130_fd_sc_hd__fill_1
XFILLER_33_132 VGND VGND VPWR VPWR sky130_fd_sc_hd__decap_3
XTAP_TAPCELL_ROW_16_352 VGND VPWR sky130_fd_sc_hd__tapvpwrvgnd_1
X_3624_ net199 net197 net181 net180 VGND VGND VPWR VPWR _1513_ sky130_fd_sc_hd__and4_1
X_3555_ _1439_ _1443_ VGND VGND VPWR VPWR _1444_ sky130_fd_sc_hd__and2_1
XFILLER_88_316 VGND VGND VPWR VPWR sky130_fd_sc_hd__decap_4
XFILLER_0_209 VPWR VGND VPWR VGND sky130_ef_sc_hd__decap_12
X_3486_ net137 _1393_ VGND VGND VPWR VPWR _1394_ sky130_fd_sc_hd__nand2_1
X_2506_ net273 net275 net270 net266 VGND VGND VPWR VPWR _0491_ sky130_fd_sc_hd__and4_1
X_2437_ _2121_ _0420_ _0421_ VGND VGND VPWR VPWR _0422_ sky130_fd_sc_hd__nand3_1
XFILLER_69_541 VPWR VGND VPWR VGND sky130_ef_sc_hd__decap_12
XFILLER_29_405 VGND VGND VPWR VPWR sky130_fd_sc_hd__decap_4
XFILLER_29_427 VPWR VGND VPWR VGND sky130_ef_sc_hd__decap_12
X_2368_ _2053_ _2065_ _2066_ VGND VGND VPWR VPWR _2067_ sky130_fd_sc_hd__nor3_1
XFILLER_84_533 VPWR VGND VPWR VGND sky130_ef_sc_hd__decap_12
X_2299_ _1957_ _1997_ VGND VGND VPWR VPWR _1998_ sky130_fd_sc_hd__nor2_1
X_4107_ net245 VGND VGND VPWR VPWR _0088_ sky130_fd_sc_hd__inv_2
XFILLER_44_419 VGND VGND VPWR VPWR sky130_fd_sc_hd__fill_1
X_4038_ net243 VGND VGND VPWR VPWR _0019_ sky130_fd_sc_hd__inv_2
XFILLER_24_176 VPWR VGND VPWR VGND sky130_ef_sc_hd__decap_12
XTAP_TAPCELL_ROW_50_675 VGND VPWR sky130_fd_sc_hd__tapvpwrvgnd_1
XFILLER_21_98 VPWR VGND VPWR VGND sky130_ef_sc_hd__decap_12
XFILLER_79_305 VGND VGND VPWR VPWR sky130_fd_sc_hd__decap_4
XFILLER_87_360 VPWR VGND VPWR VGND sky130_ef_sc_hd__decap_12
XFILLER_87_393 VGND VGND VPWR VPWR sky130_fd_sc_hd__decap_8
XTAP_TAPCELL_ROW_58_753 VGND VPWR sky130_fd_sc_hd__tapvpwrvgnd_1
XFILLER_90_525 VGND VGND VPWR VPWR sky130_fd_sc_hd__decap_6
XFILLER_28_493 VGND VGND VPWR VPWR sky130_fd_sc_hd__decap_8
XFILLER_15_198 VGND VGND VPWR VPWR sky130_fd_sc_hd__decap_4
XTAP_TAPCELL_ROW_13_322 VGND VPWR sky130_fd_sc_hd__tapvpwrvgnd_1
XFILLER_30_157 VGND VGND VPWR VPWR sky130_fd_sc_hd__fill_2
XFILLER_11_393 VPWR VGND VPWR VGND sky130_ef_sc_hd__decap_12
X_3340_ _1239_ _1240_ _1242_ VGND VGND VPWR VPWR _1261_ sky130_fd_sc_hd__a21oi_1
XTAP_TAPCELL_ROW_90_1059 VGND VPWR sky130_fd_sc_hd__tapvpwrvgnd_1
X_3271_ _1191_ VGND VGND VPWR VPWR _1192_ sky130_fd_sc_hd__inv_2
X_2222_ _1918_ _1920_ VGND VGND VPWR VPWR _1921_ sky130_fd_sc_hd__nand2b_1
XFILLER_23_3 VPWR VGND VPWR VGND sky130_ef_sc_hd__decap_12
XFILLER_66_533 VPWR VGND VPWR VGND sky130_ef_sc_hd__decap_12
XFILLER_66_522 VGND VGND VPWR VPWR sky130_fd_sc_hd__decap_8
X_2153_ net337 _1876_ net90 VGND VGND VPWR VPWR _0409_ sky130_fd_sc_hd__mux2_1
XFILLER_93_363 VGND VGND VPWR VPWR sky130_fd_sc_hd__fill_1
XFILLER_53_205 VGND VGND VPWR VPWR sky130_fd_sc_hd__decap_4
XFILLER_93_385 VGND VGND VPWR VPWR sky130_fd_sc_hd__decap_3
XFILLER_19_471 VPWR VGND VPWR VGND sky130_ef_sc_hd__decap_12
XFILLER_53_238 VGND VGND VPWR VPWR sky130_fd_sc_hd__decap_8
XFILLER_34_474 VGND VGND VPWR VPWR sky130_fd_sc_hd__fill_2
XFILLER_21_113 VPWR VGND VPWR VGND sky130_ef_sc_hd__decap_12
XFILLER_61_293 VGND VGND VPWR VPWR sky130_fd_sc_hd__decap_4
X_2986_ _0658_ _0662_ _0633_ VGND VGND VPWR VPWR _0939_ sky130_fd_sc_hd__o21a_1
X_3607_ _1495_ VGND VGND VPWR VPWR _1496_ sky130_fd_sc_hd__inv_2
X_3538_ systolic_unit_0.U_01.out_b\[5\] net191 VGND VGND VPWR VPWR _1427_ sky130_fd_sc_hd__nand2_1
XFILLER_1_529 VPWR VGND VPWR VGND sky130_ef_sc_hd__decap_12
X_3469_ net132 _1380_ VGND VGND VPWR VPWR _1381_ sky130_fd_sc_hd__nand2_1
XFILLER_57_533 VGND VGND VPWR VPWR sky130_fd_sc_hd__fill_1
XFILLER_17_408 VPWR VGND VPWR VGND sky130_ef_sc_hd__decap_12
XFILLER_29_279 VGND VGND VPWR VPWR sky130_fd_sc_hd__fill_1
XFILLER_83_27 VPWR VGND VPWR VGND sky130_ef_sc_hd__decap_12
XFILLER_72_525 VGND VGND VPWR VPWR sky130_fd_sc_hd__decap_6
XFILLER_44_216 VGND VGND VPWR VPWR sky130_fd_sc_hd__fill_1
XTAP_TAPCELL_ROW_55_723 VGND VPWR sky130_fd_sc_hd__tapvpwrvgnd_1
XTAP_TAPCELL_ROW_27_458 VGND VPWR sky130_fd_sc_hd__tapvpwrvgnd_1
XFILLER_44_249 VGND VGND VPWR VPWR sky130_fd_sc_hd__decap_3
XFILLER_16_76 VGND VGND VPWR VPWR sky130_fd_sc_hd__fill_1
XFILLER_12_135 VGND VGND VPWR VPWR sky130_fd_sc_hd__decap_4
XFILLER_40_433 VPWR VGND VPWR VGND sky130_ef_sc_hd__decap_12
XFILLER_20_190 VGND VGND VPWR VPWR sky130_fd_sc_hd__fill_2
XFILLER_4_345 VGND VGND VPWR VPWR sky130_fd_sc_hd__fill_2
XFILLER_48_511 VPWR VGND VPWR VGND sky130_ef_sc_hd__decap_12
XFILLER_48_533 VGND VGND VPWR VPWR sky130_fd_sc_hd__decap_4
XFILLER_63_547 VGND VGND VPWR VPWR sky130_fd_sc_hd__decap_3
XFILLER_90_399 VGND VGND VPWR VPWR sky130_fd_sc_hd__decap_8
X_2840_ _0780_ _0786_ VGND VGND VPWR VPWR _0793_ sky130_fd_sc_hd__xor2_1
X_2771_ _0683_ _0723_ VGND VGND VPWR VPWR _0724_ sky130_fd_sc_hd__nor2_1
X_4510_ clknet_leaf_14_clk net30 _0234_ VGND VGND VPWR VPWR systolic_unit_0.U_01.in_b\[5\]
+ sky130_fd_sc_hd__dfrtp_1
X_4441_ clknet_leaf_22_clk _0398_ _0165_ VGND VGND VPWR VPWR net60 sky130_fd_sc_hd__dfrtp_1
Xhold106 systolic_unit_0.U_11.acc_0\[1\] VGND VGND VPWR VPWR net381 sky130_fd_sc_hd__dlygate4sd3_1
Xhold117 systolic_unit_0.U_01.acc_1\[7\] VGND VGND VPWR VPWR net392 sky130_fd_sc_hd__dlygate4sd3_1
XPHY_EDGE_ROW_9_Right_9 VGND VGND VPWR VPWR sky130_fd_sc_hd__decap_3
Xhold139 systolic_unit_0.U_00.acc_1\[3\] VGND VGND VPWR VPWR net414 sky130_fd_sc_hd__dlygate4sd3_1
Xhold128 systolic_unit_0.U_11.acc_0\[11\] VGND VGND VPWR VPWR net403 sky130_fd_sc_hd__dlygate4sd3_1
X_4372_ clknet_leaf_15_clk _0345_ _0096_ VGND VGND VPWR VPWR systolic_unit_0.U_01.acc_0\[8\]
+ sky130_fd_sc_hd__dfrtp_1
X_3323_ _1224_ _1225_ _1243_ VGND VGND VPWR VPWR _1244_ sky130_fd_sc_hd__and3_1
XFILLER_85_105 VGND VGND VPWR VPWR sky130_fd_sc_hd__decap_6
X_3254_ _1131_ _1137_ _1136_ VGND VGND VPWR VPWR _1175_ sky130_fd_sc_hd__a21o_1
XFILLER_85_149 VPWR VGND VPWR VGND sky130_ef_sc_hd__decap_12
XTAP_TAPCELL_ROW_69_859 VGND VPWR sky130_fd_sc_hd__tapvpwrvgnd_1
X_2205_ net214 net257 _1902_ VGND VGND VPWR VPWR _1904_ sky130_fd_sc_hd__a21o_1
XFILLER_78_190 VGND VGND VPWR VPWR sky130_fd_sc_hd__decap_3
X_3185_ net111 net155 VGND VGND VPWR VPWR _1106_ sky130_fd_sc_hd__and2_1
X_2136_ net136 VGND VGND VPWR VPWR _1868_ sky130_fd_sc_hd__inv_2
XFILLER_93_193 VGND VGND VPWR VPWR sky130_fd_sc_hd__decap_3
XFILLER_26_238 VPWR VGND VPWR VGND sky130_ef_sc_hd__decap_12
XFILLER_81_388 VGND VGND VPWR VPWR sky130_fd_sc_hd__decap_4
XFILLER_22_411 VGND VGND VPWR VPWR sky130_fd_sc_hd__decap_8
XFILLER_22_444 VPWR VGND VPWR VGND sky130_ef_sc_hd__decap_12
XTAP_TAPCELL_ROW_24_428 VGND VPWR sky130_fd_sc_hd__tapvpwrvgnd_1
XFILLER_22_477 VPWR VGND VPWR VGND sky130_ef_sc_hd__decap_12
X_2969_ _0870_ _0890_ VGND VGND VPWR VPWR _0922_ sky130_fd_sc_hd__xor2_1
XTAP_TAPCELL_ROW_60_770 VGND VPWR sky130_fd_sc_hd__tapvpwrvgnd_1
XFILLER_5_109 VGND VGND VPWR VPWR sky130_fd_sc_hd__decap_3
XFILLER_78_27 VGND VGND VPWR VPWR sky130_fd_sc_hd__fill_1
XFILLER_1_337 VPWR VGND VPWR VGND sky130_ef_sc_hd__decap_12
XFILLER_76_149 VGND VGND VPWR VPWR sky130_fd_sc_hd__decap_3
XFILLER_76_127 VPWR VGND VPWR VGND sky130_ef_sc_hd__decap_12
XFILLER_27_97 VPWR VGND VPWR VGND sky130_ef_sc_hd__decap_12
XFILLER_43_52 VGND VGND VPWR VPWR sky130_fd_sc_hd__decap_4
XFILLER_4_197 VGND VGND VPWR VPWR sky130_fd_sc_hd__fill_2
XFILLER_68_93 VGND VGND VPWR VPWR sky130_fd_sc_hd__decap_3
XFILLER_0_370 VGND VGND VPWR VPWR sky130_fd_sc_hd__decap_4
XFILLER_67_138 VPWR VGND VPWR VGND sky130_ef_sc_hd__decap_12
XTAP_TAPCELL_ROW_89_1050 VGND VPWR sky130_fd_sc_hd__tapvpwrvgnd_1
XFILLER_75_160 VGND VGND VPWR VPWR sky130_fd_sc_hd__decap_8
XFILLER_36_525 VGND VGND VPWR VPWR sky130_fd_sc_hd__decap_6
XTAP_TAPCELL_ROW_66_829 VGND VPWR sky130_fd_sc_hd__tapvpwrvgnd_1
XFILLER_90_141 VPWR VGND VPWR VGND sky130_ef_sc_hd__decap_12
XFILLER_75_182 VPWR VGND VPWR VGND sky130_ef_sc_hd__decap_12
XFILLER_51_517 VGND VGND VPWR VPWR sky130_fd_sc_hd__fill_2
XFILLER_51_528 VGND VGND VPWR VPWR sky130_fd_sc_hd__decap_4
XFILLER_16_271 VPWR VGND VPWR VGND sky130_ef_sc_hd__decap_12
X_3941_ _1741_ _1749_ VGND VGND VPWR VPWR _1818_ sky130_fd_sc_hd__nand2_1
XFILLER_90_3 VPWR VGND VPWR VGND sky130_ef_sc_hd__decap_12
X_3872_ _1641_ _1642_ VGND VGND VPWR VPWR _1761_ sky130_fd_sc_hd__xnor2_1
X_2823_ _0771_ _0774_ _0739_ VGND VGND VPWR VPWR _0776_ sky130_fd_sc_hd__a21oi_1
X_2754_ net129 systolic_unit_0.U_00.out_a\[6\] VGND VGND VPWR VPWR _0707_ sky130_fd_sc_hd__nand2_1
X_2685_ net123 systolic_unit_0.U_00.out_a\[6\] net166 net125 VGND VGND VPWR VPWR _0638_
+ sky130_fd_sc_hd__a22oi_1
X_4424_ clknet_leaf_9_clk net219 _0148_ VGND VGND VPWR VPWR systolic_unit_0.U_00.out_a\[4\]
+ sky130_fd_sc_hd__dfrtp_1
X_4355_ clknet_leaf_12_clk _0328_ _0079_ VGND VGND VPWR VPWR systolic_unit_0.U_01.acc_1\[7\]
+ sky130_fd_sc_hd__dfrtp_1
X_3306_ net161 net110 net108 net163 VGND VGND VPWR VPWR _1227_ sky130_fd_sc_hd__a22o_1
XFILLER_86_447 VGND VGND VPWR VPWR sky130_fd_sc_hd__decap_4
X_4286_ clknet_leaf_24_clk _0267_ VGND VGND VPWR VPWR matrix_count\[1\] sky130_fd_sc_hd__dfxtp_1
XFILLER_86_469 VGND VGND VPWR VPWR sky130_fd_sc_hd__decap_6
XFILLER_86_458 VGND VGND VPWR VPWR sky130_fd_sc_hd__fill_1
XFILLER_73_108 VGND VGND VPWR VPWR sky130_fd_sc_hd__decap_4
X_3237_ _1149_ _1151_ _1156_ _1157_ VGND VGND VPWR VPWR _1158_ sky130_fd_sc_hd__a211oi_2
X_3168_ _1081_ _1082_ _1088_ _1087_ _1062_ VGND VGND VPWR VPWR _1089_ sky130_fd_sc_hd__a32o_1
XFILLER_64_29 VPWR VGND VPWR VGND sky130_ef_sc_hd__decap_12
X_3099_ net157 net101 _1019_ VGND VGND VPWR VPWR _1020_ sky130_fd_sc_hd__and3_1
XTAP_TAPCELL_ROW_37_553 VGND VPWR sky130_fd_sc_hd__tapvpwrvgnd_1
XFILLER_54_399 VPWR VGND VPWR VGND sky130_ef_sc_hd__decap_12
XFILLER_13_33 VGND VGND VPWR VPWR sky130_fd_sc_hd__decap_3
XFILLER_13_11 VGND VGND VPWR VPWR sky130_fd_sc_hd__decap_3
XFILLER_10_414 VGND VGND VPWR VPWR sky130_fd_sc_hd__decap_6
Xfanout89 _1901_ VGND VGND VPWR VPWR net89 sky130_fd_sc_hd__clkbuf_2
Xfanout78 _0976_ VGND VGND VPWR VPWR net78 sky130_fd_sc_hd__clkbuf_2
XFILLER_10_469 VGND VGND VPWR VPWR sky130_fd_sc_hd__decap_6
XFILLER_89_15 VPWR VGND VPWR VGND sky130_ef_sc_hd__decap_12
XTAP_TAPCELL_ROW_9_289 VGND VPWR sky130_fd_sc_hd__tapvpwrvgnd_1
XFILLER_89_296 VGND VGND VPWR VPWR sky130_fd_sc_hd__fill_1
XFILLER_77_447 VGND VGND VPWR VPWR sky130_fd_sc_hd__fill_1
XFILLER_38_63 VPWR VGND VPWR VGND sky130_ef_sc_hd__decap_12
XFILLER_38_85 VGND VGND VPWR VPWR sky130_fd_sc_hd__decap_4
XFILLER_45_311 VGND VGND VPWR VPWR sky130_fd_sc_hd__decap_6
XFILLER_64_108 VPWR VGND VPWR VGND sky130_ef_sc_hd__decap_12
XTAP_TAPCELL_ROW_71_876 VGND VPWR sky130_fd_sc_hd__tapvpwrvgnd_1
XFILLER_9_223 VGND VGND VPWR VPWR sky130_fd_sc_hd__fill_1
Xclkload15 clknet_leaf_29_clk VGND VGND VPWR VPWR clkload15/Y sky130_fd_sc_hd__inv_6
Xclkload26 clknet_leaf_18_clk VGND VGND VPWR VPWR clkload26/Y sky130_fd_sc_hd__clkinvlp_4
XFILLER_5_473 VPWR VGND VPWR VGND sky130_ef_sc_hd__decap_12
X_2470_ _0421_ _0452_ _0453_ _0454_ VGND VGND VPWR VPWR _0455_ sky130_fd_sc_hd__nor4_1
XFILLER_79_81 VGND VGND VPWR VPWR sky130_fd_sc_hd__fill_2
X_4140_ net246 VGND VGND VPWR VPWR _0121_ sky130_fd_sc_hd__inv_2
XTAP_TAPCELL_ROW_79_954 VGND VPWR sky130_fd_sc_hd__tapvpwrvgnd_1
X_4071_ net228 VGND VGND VPWR VPWR _0052_ sky130_fd_sc_hd__inv_2
X_3022_ _0921_ _0922_ VGND VGND VPWR VPWR _0966_ sky130_fd_sc_hd__xor2_1
XFILLER_91_461 VPWR VGND VPWR VGND sky130_ef_sc_hd__decap_12
XFILLER_36_377 VGND VGND VPWR VPWR sky130_fd_sc_hd__decap_3
XTAP_TAPCELL_ROW_34_523 VGND VPWR sky130_fd_sc_hd__tapvpwrvgnd_1
X_3924_ systolic_unit_0.U_01.acc_0\[8\] _1784_ _1787_ systolic_unit_0.U_11.acc_0\[8\]
+ VGND VGND VPWR VPWR _1806_ sky130_fd_sc_hd__a22o_1
Xclkload9 clknet_leaf_32_clk VGND VGND VPWR VPWR clkload9/X sky130_fd_sc_hd__clkbuf_4
X_3855_ _1725_ _1727_ VGND VGND VPWR VPWR _1744_ sky130_fd_sc_hd__xnor2_1
X_2806_ net174 net120 systolic_unit_0.U_01.in_b\[6\] net175 VGND VGND VPWR VPWR _0759_
+ sky130_fd_sc_hd__a22oi_1
X_3786_ net190 net198 _1673_ VGND VGND VPWR VPWR _1675_ sky130_fd_sc_hd__and3_1
X_2737_ _0684_ _0688_ VGND VGND VPWR VPWR _0690_ sky130_fd_sc_hd__xnor2_1
X_2668_ net167 net121 _0592_ VGND VGND VPWR VPWR _0621_ sky130_fd_sc_hd__and3_1
X_4407_ clknet_leaf_4_clk _0372_ _0131_ VGND VGND VPWR VPWR systolic_unit_0.U_00.acc_0\[3\]
+ sky130_fd_sc_hd__dfrtp_1
XFILLER_59_18 VPWR VGND VPWR VGND sky130_ef_sc_hd__decap_12
Xfanout213 net8 VGND VGND VPWR VPWR net213 sky130_fd_sc_hd__buf_2
Xfanout202 systolic_unit_0.U_10.out_a\[1\] VGND VGND VPWR VPWR net202 sky130_fd_sc_hd__buf_2
X_2599_ net408 net88 _0577_ net208 VGND VGND VPWR VPWR _0378_ sky130_fd_sc_hd__a22o_1
Xfanout235 net236 VGND VGND VPWR VPWR net235 sky130_fd_sc_hd__buf_4
XTAP_TAPCELL_ROW_6_259 VGND VPWR sky130_fd_sc_hd__tapvpwrvgnd_1
X_4338_ clknet_leaf_2_clk _0319_ _0062_ VGND VGND VPWR VPWR systolic_unit_0.U_10.acc_0\[14\]
+ sky130_fd_sc_hd__dfrtp_1
Xfanout224 net226 VGND VGND VPWR VPWR net224 sky130_fd_sc_hd__buf_2
Xfanout246 net247 VGND VGND VPWR VPWR net246 sky130_fd_sc_hd__clkbuf_4
XFILLER_86_233 VPWR VGND VPWR VGND sky130_ef_sc_hd__decap_12
Xfanout268 net269 VGND VGND VPWR VPWR net268 sky130_fd_sc_hd__buf_2
Xfanout257 net24 VGND VGND VPWR VPWR net257 sky130_fd_sc_hd__clkbuf_2
X_4269_ clknet_leaf_19_clk _0250_ _0005_ VGND VGND VPWR VPWR systolic_unit_0.U_11.acc_1\[5\]
+ sky130_fd_sc_hd__dfrtp_1
XFILLER_74_439 VGND VGND VPWR VPWR sky130_fd_sc_hd__decap_4
XFILLER_46_108 VPWR VGND VPWR VGND sky130_ef_sc_hd__decap_12
XFILLER_15_517 VPWR VGND VPWR VGND sky130_ef_sc_hd__decap_12
XFILLER_91_27 VPWR VGND VPWR VGND sky130_ef_sc_hd__decap_12
XFILLER_10_244 VGND VGND VPWR VPWR sky130_fd_sc_hd__decap_8
XFILLER_10_277 VGND VGND VPWR VPWR sky130_fd_sc_hd__decap_6
XFILLER_2_421 VPWR VGND VPWR VGND sky130_ef_sc_hd__decap_12
XFILLER_77_211 VPWR VGND VPWR VGND sky130_ef_sc_hd__decap_12
XTAP_TAPCELL_ROW_76_924 VGND VPWR sky130_fd_sc_hd__tapvpwrvgnd_1
XFILLER_92_258 VPWR VGND VPWR VGND sky130_ef_sc_hd__decap_12
XTAP_TAPCELL_ROW_86_1020 VGND VPWR sky130_fd_sc_hd__tapvpwrvgnd_1
XFILLER_1_69 VPWR VGND VPWR VGND sky130_ef_sc_hd__decap_12
XTAP_TAPCELL_ROW_48_659 VGND VPWR sky130_fd_sc_hd__tapvpwrvgnd_1
XFILLER_80_409 VGND VGND VPWR VPWR sky130_fd_sc_hd__decap_8
XFILLER_45_152 VGND VGND VPWR VPWR sky130_fd_sc_hd__decap_8
XFILLER_60_155 VPWR VGND VPWR VGND sky130_ef_sc_hd__decap_12
XFILLER_81_93 VPWR VGND VPWR VGND sky130_ef_sc_hd__decap_12
X_3640_ _1527_ _1528_ VGND VGND VPWR VPWR _1529_ sky130_fd_sc_hd__or2_1
X_3571_ _1454_ _1459_ VGND VGND VPWR VPWR _1460_ sky130_fd_sc_hd__or2_1
XFILLER_53_3 VPWR VGND VPWR VGND sky130_ef_sc_hd__decap_12
X_2522_ _0503_ _0506_ VGND VGND VPWR VPWR _0507_ sky130_fd_sc_hd__and2_1
XFILLER_5_281 VGND VGND VPWR VPWR sky130_fd_sc_hd__decap_6
X_2453_ _0417_ _0418_ _0429_ net73 VGND VGND VPWR VPWR _0438_ sky130_fd_sc_hd__a211oi_1
X_2384_ _2042_ _2077_ _2082_ VGND VGND VPWR VPWR _2083_ sky130_fd_sc_hd__nand3_1
XFILLER_68_244 VGND VGND VPWR VPWR sky130_fd_sc_hd__fill_1
XFILLER_68_233 VGND VGND VPWR VPWR sky130_fd_sc_hd__decap_4
X_4123_ net229 VGND VGND VPWR VPWR _0104_ sky130_fd_sc_hd__inv_2
XTAP_TAPCELL_ROW_3_229 VGND VPWR sky130_fd_sc_hd__tapvpwrvgnd_1
X_4054_ net238 VGND VGND VPWR VPWR _0035_ sky130_fd_sc_hd__inv_2
XFILLER_56_428 VGND VGND VPWR VPWR sky130_fd_sc_hd__fill_1
Xinput2 D_a_00[1] VGND VGND VPWR VPWR net2 sky130_fd_sc_hd__clkbuf_1
X_3005_ systolic_unit_0.U_01.acc_0\[13\] net84 _0955_ net139 VGND VGND VPWR VPWR _0350_
+ sky130_fd_sc_hd__a22o_1
XFILLER_36_130 VGND VGND VPWR VPWR sky130_fd_sc_hd__decap_3
XTAP_TAPCELL_ROW_19_383 VGND VPWR sky130_fd_sc_hd__tapvpwrvgnd_1
XFILLER_24_303 VGND VGND VPWR VPWR sky130_fd_sc_hd__decap_4
XFILLER_36_174 VGND VGND VPWR VPWR sky130_fd_sc_hd__decap_3
XFILLER_24_347 VPWR VGND VPWR VGND sky130_ef_sc_hd__decap_12
XFILLER_51_122 VGND VGND VPWR VPWR sky130_fd_sc_hd__decap_4
X_3907_ net148 _1792_ _1793_ VGND VGND VPWR VPWR _0286_ sky130_fd_sc_hd__a21o_1
XFILLER_20_553 VGND VGND VPWR VPWR sky130_fd_sc_hd__fill_1
X_3838_ _1724_ _1726_ VGND VGND VPWR VPWR _1727_ sky130_fd_sc_hd__nor2_1
X_3769_ systolic_unit_0.U_11.acc_1\[4\] systolic_unit_0.U_11.acc_0\[4\] net146 VGND
+ VGND VPWR VPWR _1658_ sky130_fd_sc_hd__mux2_1
XFILLER_86_27 VGND VGND VPWR VPWR sky130_fd_sc_hd__fill_1
XFILLER_87_553 VGND VGND VPWR VPWR sky130_fd_sc_hd__fill_1
XFILLER_19_65 VPWR VGND VPWR VGND sky130_ef_sc_hd__decap_12
XFILLER_19_87 VGND VGND VPWR VPWR sky130_fd_sc_hd__decap_8
XFILLER_55_461 VGND VGND VPWR VPWR sky130_fd_sc_hd__fill_2
XFILLER_15_314 VPWR VGND VPWR VGND sky130_ef_sc_hd__decap_12
XTAP_TAPCELL_ROW_45_629 VGND VPWR sky130_fd_sc_hd__tapvpwrvgnd_1
XTAP_TAPCELL_ROW_81_971 VGND VPWR sky130_fd_sc_hd__tapvpwrvgnd_1
XFILLER_42_188 VGND VGND VPWR VPWR sky130_fd_sc_hd__decap_8
XFILLER_11_553 VGND VGND VPWR VPWR sky130_fd_sc_hd__fill_1
XPHY_EDGE_ROW_2_Left_96 VGND VGND VPWR VPWR sky130_fd_sc_hd__decap_3
XFILLER_78_553 VGND VGND VPWR VPWR sky130_fd_sc_hd__fill_1
XFILLER_78_531 VGND VGND VPWR VPWR sky130_fd_sc_hd__fill_1
XFILLER_93_501 VGND VGND VPWR VPWR sky130_fd_sc_hd__decap_3
XFILLER_93_545 VGND VGND VPWR VPWR sky130_fd_sc_hd__decap_8
XFILLER_76_71 VGND VGND VPWR VPWR sky130_fd_sc_hd__decap_8
XFILLER_65_225 VGND VGND VPWR VPWR sky130_fd_sc_hd__fill_1
XFILLER_18_141 VPWR VGND VPWR VGND sky130_ef_sc_hd__decap_12
XTAP_TAPCELL_ROW_16_353 VGND VPWR sky130_fd_sc_hd__tapvpwrvgnd_1
XFILLER_33_166 VGND VGND VPWR VPWR sky130_fd_sc_hd__fill_2
XFILLER_33_177 VGND VGND VPWR VPWR sky130_fd_sc_hd__decap_8
XFILLER_33_199 VPWR VGND VPWR VGND sky130_ef_sc_hd__decap_12
X_3623_ _1510_ _1511_ _1505_ VGND VGND VPWR VPWR _1512_ sky130_fd_sc_hd__a21o_1
X_3554_ _1437_ _1438_ VGND VGND VPWR VPWR _1443_ sky130_fd_sc_hd__or2_1
XFILLER_88_306 VGND VGND VPWR VPWR sky130_fd_sc_hd__fill_2
X_3485_ _1323_ _1392_ VGND VGND VPWR VPWR _1393_ sky130_fd_sc_hd__or2_1
X_2505_ _0480_ _0481_ VGND VGND VPWR VPWR _0490_ sky130_fd_sc_hd__xor2_1
X_2436_ net274 net266 net268 net265 VGND VGND VPWR VPWR _0421_ sky130_fd_sc_hd__and4_1
XFILLER_69_553 VGND VGND VPWR VPWR sky130_fd_sc_hd__fill_1
XFILLER_84_501 VPWR VGND VPWR VGND sky130_ef_sc_hd__decap_12
XPHY_EDGE_ROW_16_Left_110 VGND VGND VPWR VPWR sky130_fd_sc_hd__decap_3
X_2367_ _2013_ _2037_ _2052_ VGND VGND VPWR VPWR _2066_ sky130_fd_sc_hd__a21oi_1
XFILLER_84_545 VGND VGND VPWR VPWR sky130_fd_sc_hd__decap_8
X_2298_ _1995_ _1996_ VGND VGND VPWR VPWR _1997_ sky130_fd_sc_hd__or2_1
XFILLER_29_439 VGND VGND VPWR VPWR sky130_fd_sc_hd__fill_2
X_4106_ net249 VGND VGND VPWR VPWR _0087_ sky130_fd_sc_hd__inv_2
X_4037_ net243 VGND VGND VPWR VPWR _0018_ sky130_fd_sc_hd__inv_2
XFILLER_56_269 VGND VGND VPWR VPWR sky130_fd_sc_hd__fill_1
XFILLER_24_100 VGND VGND VPWR VPWR sky130_fd_sc_hd__decap_3
XFILLER_37_483 VGND VGND VPWR VPWR sky130_fd_sc_hd__fill_1
XFILLER_24_133 VGND VGND VPWR VPWR sky130_fd_sc_hd__decap_3
XFILLER_52_442 VGND VGND VPWR VPWR sky130_fd_sc_hd__fill_1
XFILLER_64_291 VGND VGND VPWR VPWR sky130_fd_sc_hd__decap_3
XFILLER_12_306 VGND VGND VPWR VPWR sky130_fd_sc_hd__fill_2
XFILLER_52_475 VGND VGND VPWR VPWR sky130_fd_sc_hd__fill_1
XFILLER_24_188 VGND VGND VPWR VPWR sky130_fd_sc_hd__decap_8
XTAP_TAPCELL_ROW_50_676 VGND VPWR sky130_fd_sc_hd__tapvpwrvgnd_1
XFILLER_20_372 VPWR VGND VPWR VGND sky130_ef_sc_hd__decap_12
XFILLER_21_44 VGND VGND VPWR VPWR sky130_fd_sc_hd__decap_4
XFILLER_21_55 VGND VGND VPWR VPWR sky130_fd_sc_hd__fill_1
XFILLER_79_317 VPWR VGND VPWR VGND sky130_ef_sc_hd__decap_12
XFILLER_87_372 VGND VGND VPWR VPWR sky130_fd_sc_hd__fill_2
XFILLER_47_225 VGND VGND VPWR VPWR sky130_fd_sc_hd__decap_4
XFILLER_28_450 VPWR VGND VPWR VGND sky130_ef_sc_hd__decap_12
XTAP_TAPCELL_ROW_58_754 VGND VPWR sky130_fd_sc_hd__tapvpwrvgnd_1
XFILLER_28_472 VGND VGND VPWR VPWR sky130_fd_sc_hd__decap_4
XFILLER_28_483 VGND VGND VPWR VPWR sky130_fd_sc_hd__fill_1
Xmax_cap86 net87 VGND VGND VPWR VPWR net86 sky130_fd_sc_hd__clkbuf_1
XFILLER_15_166 VGND VGND VPWR VPWR sky130_fd_sc_hd__fill_2
XFILLER_43_486 VGND VGND VPWR VPWR sky130_fd_sc_hd__decap_3
XTAP_TAPCELL_ROW_13_323 VGND VPWR sky130_fd_sc_hd__tapvpwrvgnd_1
XFILLER_30_147 VGND VGND VPWR VPWR sky130_fd_sc_hd__fill_1
XFILLER_7_321 VPWR VGND VPWR VGND sky130_ef_sc_hd__decap_12
XFILLER_7_57 VPWR VGND VPWR VGND sky130_ef_sc_hd__decap_12
X_3270_ _1176_ _1190_ _1154_ _1167_ VGND VGND VPWR VPWR _1191_ sky130_fd_sc_hd__a211oi_2
X_2221_ _1912_ _1919_ VGND VGND VPWR VPWR _1920_ sky130_fd_sc_hd__and2_1
XFILLER_87_81 VPWR VGND VPWR VGND sky130_ef_sc_hd__decap_12
XFILLER_66_545 VGND VGND VPWR VPWR sky130_fd_sc_hd__decap_8
X_2152_ systolic_unit_0.out_acc_0_r1\[8\] systolic_unit_0.out_acc_1_r1\[8\] net143
+ VGND VGND VPWR VPWR _1876_ sky130_fd_sc_hd__mux2_1
XFILLER_16_3 VGND VGND VPWR VPWR sky130_fd_sc_hd__decap_4
XFILLER_19_483 VPWR VGND VPWR VGND sky130_ef_sc_hd__decap_12
XFILLER_21_125 VPWR VGND VPWR VGND sky130_ef_sc_hd__decap_12
X_2985_ _0738_ _0936_ _0937_ VGND VGND VPWR VPWR _0938_ sky130_fd_sc_hd__and3_1
X_3606_ _1490_ _1494_ _1466_ VGND VGND VPWR VPWR _1495_ sky130_fd_sc_hd__o21ai_1
X_3537_ _1424_ _1425_ VGND VGND VPWR VPWR _1426_ sky130_fd_sc_hd__nand2_1
X_3468_ _1283_ _1327_ VGND VGND VPWR VPWR _1380_ sky130_fd_sc_hd__xor2_2
X_3399_ systolic_unit_0.U_10.acc_1\[0\] systolic_unit_0.U_10.acc_0\[0\] net135 VGND
+ VGND VPWR VPWR _1320_ sky130_fd_sc_hd__mux2_1
X_2419_ net274 net266 net265 net262 VGND VGND VPWR VPWR _2118_ sky130_fd_sc_hd__nand4_1
XFILLER_84_353 VGND VGND VPWR VPWR sky130_fd_sc_hd__fill_1
XFILLER_84_397 VGND VGND VPWR VPWR sky130_fd_sc_hd__decap_4
XFILLER_83_39 VPWR VGND VPWR VGND sky130_ef_sc_hd__decap_12
XTAP_TAPCELL_ROW_55_724 VGND VPWR sky130_fd_sc_hd__tapvpwrvgnd_1
XTAP_TAPCELL_ROW_27_459 VGND VPWR sky130_fd_sc_hd__tapvpwrvgnd_1
XFILLER_25_475 VPWR VGND VPWR VGND sky130_ef_sc_hd__decap_12
XFILLER_40_445 VGND VGND VPWR VPWR sky130_fd_sc_hd__decap_8
XFILLER_79_125 VGND VGND VPWR VPWR sky130_fd_sc_hd__fill_1
XFILLER_79_169 VPWR VGND VPWR VGND sky130_ef_sc_hd__decap_12
XFILLER_48_523 VGND VGND VPWR VPWR sky130_fd_sc_hd__decap_8
XFILLER_75_342 VGND VGND VPWR VPWR sky130_fd_sc_hd__decap_8
XFILLER_75_375 VPWR VGND VPWR VGND sky130_ef_sc_hd__decap_12
XFILLER_35_228 VGND VGND VPWR VPWR sky130_fd_sc_hd__decap_8
XFILLER_16_475 VGND VGND VPWR VPWR sky130_fd_sc_hd__fill_1
XFILLER_31_456 VGND VGND VPWR VPWR sky130_fd_sc_hd__decap_8
X_2770_ net174 net118 _0681_ _0682_ VGND VGND VPWR VPWR _0723_ sky130_fd_sc_hd__o2bb2a_1
XFILLER_7_140 VPWR VGND VPWR VGND sky130_ef_sc_hd__decap_12
Xhold107 _0274_ VGND VGND VPWR VPWR net382 sky130_fd_sc_hd__dlygate4sd3_1
X_4440_ clknet_leaf_16_clk _0397_ _0164_ VGND VGND VPWR VPWR net59 sky130_fd_sc_hd__dfrtp_1
Xhold118 systolic_unit_0.U_01.acc_0\[11\] VGND VGND VPWR VPWR net393 sky130_fd_sc_hd__dlygate4sd3_1
Xhold129 systolic_unit_0.U_01.acc_0\[3\] VGND VGND VPWR VPWR net404 sky130_fd_sc_hd__dlygate4sd3_1
X_4371_ clknet_leaf_13_clk _0344_ _0095_ VGND VGND VPWR VPWR systolic_unit_0.U_01.acc_0\[7\]
+ sky130_fd_sc_hd__dfrtp_1
X_3322_ _1239_ _1240_ _1242_ VGND VGND VPWR VPWR _1243_ sky130_fd_sc_hd__and3_4
X_3253_ _1170_ _1171_ _1173_ VGND VGND VPWR VPWR _1174_ sky130_fd_sc_hd__nand3_1
XFILLER_58_309 VPWR VGND VPWR VGND sky130_ef_sc_hd__decap_12
X_2204_ net214 net256 _1902_ VGND VGND VPWR VPWR _1903_ sky130_fd_sc_hd__nand3_1
X_3184_ net115 net113 net154 net152 VGND VGND VPWR VPWR _1105_ sky130_fd_sc_hd__nand4_1
X_2135_ net240 VGND VGND VPWR VPWR _0000_ sky130_fd_sc_hd__inv_2
XFILLER_26_217 VGND VGND VPWR VPWR sky130_fd_sc_hd__fill_1
XFILLER_54_548 VGND VGND VPWR VPWR sky130_fd_sc_hd__fill_2
XFILLER_34_250 VGND VGND VPWR VPWR sky130_fd_sc_hd__fill_2
XTAP_TAPCELL_ROW_24_429 VGND VPWR sky130_fd_sc_hd__tapvpwrvgnd_1
XFILLER_22_456 VPWR VGND VPWR VGND sky130_ef_sc_hd__decap_12
X_2968_ _0892_ _0918_ _0920_ _0907_ VGND VGND VPWR VPWR _0921_ sky130_fd_sc_hd__o31ai_2
XFILLER_22_489 VGND VGND VPWR VPWR sky130_fd_sc_hd__decap_3
XTAP_TAPCELL_ROW_60_771 VGND VPWR sky130_fd_sc_hd__tapvpwrvgnd_1
X_2899_ _0845_ _0851_ VGND VGND VPWR VPWR _0852_ sky130_fd_sc_hd__nand2_1
XFILLER_89_456 VPWR VGND VPWR VGND sky130_ef_sc_hd__decap_12
XFILLER_1_349 VGND VGND VPWR VPWR sky130_fd_sc_hd__decap_4
XFILLER_76_139 VGND VGND VPWR VPWR sky130_fd_sc_hd__fill_1
XFILLER_32_209 VGND VGND VPWR VPWR sky130_fd_sc_hd__decap_4
XFILLER_60_529 VGND VGND VPWR VPWR sky130_fd_sc_hd__decap_3
XFILLER_9_405 VPWR VGND VPWR VGND sky130_ef_sc_hd__decap_12
XFILLER_40_253 VGND VGND VPWR VPWR sky130_fd_sc_hd__decap_3
XFILLER_9_449 VPWR VGND VPWR VGND sky130_ef_sc_hd__decap_12
XFILLER_68_83 VGND VGND VPWR VPWR sky130_fd_sc_hd__fill_1
XFILLER_0_393 VGND VGND VPWR VPWR sky130_fd_sc_hd__fill_2
XTAP_TAPCELL_ROW_89_1051 VGND VPWR sky130_fd_sc_hd__tapvpwrvgnd_1
XFILLER_82_109 VPWR VGND VPWR VGND sky130_ef_sc_hd__decap_12
XFILLER_63_301 VGND VGND VPWR VPWR sky130_fd_sc_hd__fill_2
XFILLER_75_194 VPWR VGND VPWR VGND sky130_ef_sc_hd__decap_12
XFILLER_63_334 VGND VGND VPWR VPWR sky130_fd_sc_hd__fill_2
XFILLER_90_153 VPWR VGND VPWR VGND sky130_ef_sc_hd__decap_12
X_3940_ net146 _1816_ _1817_ VGND VGND VPWR VPWR _0277_ sky130_fd_sc_hd__a21o_1
XFILLER_63_378 VGND VGND VPWR VPWR sky130_fd_sc_hd__fill_1
XFILLER_90_197 VPWR VGND VPWR VGND sky130_ef_sc_hd__decap_12
XFILLER_16_283 VGND VGND VPWR VPWR sky130_fd_sc_hd__decap_6
X_3871_ _1701_ _1759_ VGND VGND VPWR VPWR _1760_ sky130_fd_sc_hd__and2_1
XFILLER_83_3 VPWR VGND VPWR VGND sky130_ef_sc_hd__decap_12
X_2822_ _0739_ _0771_ _0774_ VGND VGND VPWR VPWR _0775_ sky130_fd_sc_hd__and3_1
X_2753_ net131 net165 _0704_ VGND VGND VPWR VPWR _0706_ sky130_fd_sc_hd__and3_1
X_2684_ _0615_ _0636_ VGND VGND VPWR VPWR _0637_ sky130_fd_sc_hd__nor2_1
X_4423_ clknet_leaf_9_clk net221 _0147_ VGND VGND VPWR VPWR systolic_unit_0.U_00.out_a\[3\]
+ sky130_fd_sc_hd__dfrtp_1
X_4354_ clknet_leaf_12_clk _0327_ _0078_ VGND VGND VPWR VPWR systolic_unit_0.U_01.acc_1\[6\]
+ sky130_fd_sc_hd__dfrtp_1
XFILLER_86_415 VGND VGND VPWR VPWR sky130_fd_sc_hd__decap_4
X_3305_ net163 net161 net110 net108 VGND VGND VPWR VPWR _1226_ sky130_fd_sc_hd__nand4_1
X_4285_ clknet_leaf_24_clk _0266_ VGND VGND VPWR VPWR matrix_count\[0\] sky130_fd_sc_hd__dfxtp_1
X_3236_ _1120_ _1126_ _1140_ _1155_ VGND VGND VPWR VPWR _1157_ sky130_fd_sc_hd__o211a_1
XFILLER_39_353 VGND VGND VPWR VPWR sky130_fd_sc_hd__decap_4
X_3167_ _1062_ _1087_ VGND VGND VPWR VPWR _1088_ sky130_fd_sc_hd__xor2_1
XFILLER_39_364 VPWR VGND VPWR VGND sky130_ef_sc_hd__decap_12
X_3098_ _1013_ _1017_ VGND VGND VPWR VPWR _1019_ sky130_fd_sc_hd__xnor2_1
XTAP_TAPCELL_ROW_37_554 VGND VPWR sky130_fd_sc_hd__tapvpwrvgnd_1
XFILLER_42_529 VGND VGND VPWR VPWR sky130_fd_sc_hd__decap_3
XFILLER_80_29 VPWR VGND VPWR VGND sky130_ef_sc_hd__decap_12
Xfanout79 _0590_ VGND VGND VPWR VPWR net79 sky130_fd_sc_hd__clkbuf_4
XFILLER_6_419 VGND VGND VPWR VPWR sky130_fd_sc_hd__fill_1
XFILLER_89_27 VPWR VGND VPWR VGND sky130_ef_sc_hd__decap_12
XPHY_EDGE_ROW_8_Left_102 VGND VGND VPWR VPWR sky130_fd_sc_hd__decap_3
XFILLER_1_113 VPWR VGND VPWR VGND sky130_ef_sc_hd__decap_12
XFILLER_1_157 VGND VGND VPWR VPWR sky130_fd_sc_hd__fill_1
XFILLER_38_42 VGND VGND VPWR VPWR sky130_fd_sc_hd__fill_1
XFILLER_38_75 VGND VGND VPWR VPWR sky130_fd_sc_hd__decap_8
XFILLER_85_481 VPWR VGND VPWR VGND sky130_ef_sc_hd__decap_12
XFILLER_54_41 VPWR VGND VPWR VGND sky130_ef_sc_hd__decap_12
XFILLER_72_197 VGND VGND VPWR VPWR sky130_fd_sc_hd__decap_3
XTAP_TAPCELL_ROW_0_190 VGND VPWR sky130_fd_sc_hd__tapvpwrvgnd_1
XTAP_TAPCELL_ROW_71_877 VGND VPWR sky130_fd_sc_hd__tapvpwrvgnd_1
XFILLER_13_220 VGND VGND VPWR VPWR sky130_fd_sc_hd__decap_4
XFILLER_54_85 VGND VGND VPWR VPWR sky130_fd_sc_hd__fill_1
XFILLER_9_268 VPWR VGND VPWR VGND sky130_ef_sc_hd__decap_12
Xclkload16 clknet_leaf_30_clk VGND VGND VPWR VPWR clkload16/Y sky130_fd_sc_hd__inv_8
Xclkload27 clknet_leaf_19_clk VGND VGND VPWR VPWR clkload27/Y sky130_fd_sc_hd__inv_6
XFILLER_5_441 VGND VGND VPWR VPWR sky130_fd_sc_hd__decap_6
XFILLER_5_485 VPWR VGND VPWR VGND sky130_ef_sc_hd__decap_12
XFILLER_79_93 VGND VGND VPWR VPWR sky130_fd_sc_hd__decap_8
XTAP_TAPCELL_ROW_79_955 VGND VPWR sky130_fd_sc_hd__tapvpwrvgnd_1
X_4070_ net238 VGND VGND VPWR VPWR _0051_ sky130_fd_sc_hd__inv_2
X_3021_ net391 net84 _0965_ net140 VGND VGND VPWR VPWR _0344_ sky130_fd_sc_hd__a22o_1
XFILLER_48_194 VGND VGND VPWR VPWR sky130_fd_sc_hd__fill_2
XFILLER_91_473 VPWR VGND VPWR VGND sky130_ef_sc_hd__decap_12
XTAP_TAPCELL_ROW_34_524 VGND VPWR sky130_fd_sc_hd__tapvpwrvgnd_1
XFILLER_51_337 VPWR VGND VPWR VGND sky130_ef_sc_hd__decap_12
X_3923_ _1760_ _1763_ VGND VGND VPWR VPWR _1805_ sky130_fd_sc_hd__xnor2_1
X_3854_ _1731_ _1742_ VGND VGND VPWR VPWR _1743_ sky130_fd_sc_hd__nor2_1
X_2805_ net175 net174 net120 systolic_unit_0.U_01.in_b\[6\] VGND VGND VPWR VPWR _0758_
+ sky130_fd_sc_hd__and4_1
X_3785_ net190 net198 VGND VGND VPWR VPWR _1674_ sky130_fd_sc_hd__nand2_1
X_2736_ _0684_ _0688_ VGND VGND VPWR VPWR _0689_ sky130_fd_sc_hd__and2b_1
XFILLER_8_290 VPWR VGND VPWR VGND sky130_ef_sc_hd__decap_12
X_2667_ _0599_ _0619_ VGND VGND VPWR VPWR _0620_ sky130_fd_sc_hd__nor2_1
X_4406_ clknet_leaf_11_clk _0371_ _0130_ VGND VGND VPWR VPWR systolic_unit_0.U_00.acc_0\[2\]
+ sky130_fd_sc_hd__dfrtp_1
Xfanout214 net7 VGND VGND VPWR VPWR net214 sky130_fd_sc_hd__buf_2
Xfanout203 systolic_unit_0.U_10.out_a\[1\] VGND VGND VPWR VPWR net203 sky130_fd_sc_hd__dlymetal6s2s_1
X_2598_ _0532_ _0576_ VGND VGND VPWR VPWR _0577_ sky130_fd_sc_hd__xnor2_1
X_4337_ clknet_leaf_1_clk _0318_ _0061_ VGND VGND VPWR VPWR systolic_unit_0.U_10.acc_0\[13\]
+ sky130_fd_sc_hd__dfrtp_1
Xfanout225 net226 VGND VGND VPWR VPWR net225 sky130_fd_sc_hd__buf_4
Xfanout236 net253 VGND VGND VPWR VPWR net236 sky130_fd_sc_hd__clkbuf_4
Xfanout247 net252 VGND VGND VPWR VPWR net247 sky130_fd_sc_hd__buf_4
XFILLER_86_245 VGND VGND VPWR VPWR sky130_fd_sc_hd__decap_6
Xfanout269 net19 VGND VGND VPWR VPWR net269 sky130_fd_sc_hd__buf_2
Xfanout258 net259 VGND VGND VPWR VPWR net258 sky130_fd_sc_hd__buf_2
X_4268_ clknet_leaf_20_clk _0249_ _0004_ VGND VGND VPWR VPWR systolic_unit_0.U_11.acc_1\[4\]
+ sky130_fd_sc_hd__dfrtp_1
X_3219_ _1113_ _1127_ _1139_ VGND VGND VPWR VPWR _1140_ sky130_fd_sc_hd__nand3_2
X_4199_ net231 VGND VGND VPWR VPWR _0180_ sky130_fd_sc_hd__inv_2
XFILLER_82_440 VGND VGND VPWR VPWR sky130_fd_sc_hd__decap_8
XFILLER_91_39 VPWR VGND VPWR VGND sky130_ef_sc_hd__decap_12
XFILLER_82_473 VGND VGND VPWR VPWR sky130_fd_sc_hd__decap_3
XFILLER_15_529 VPWR VGND VPWR VGND sky130_ef_sc_hd__decap_12
XFILLER_54_175 VGND VGND VPWR VPWR sky130_fd_sc_hd__fill_2
XFILLER_2_433 VPWR VGND VPWR VGND sky130_ef_sc_hd__decap_12
XFILLER_77_223 VGND VGND VPWR VPWR sky130_fd_sc_hd__fill_1
XFILLER_2_477 VPWR VGND VPWR VGND sky130_ef_sc_hd__decap_12
XTAP_TAPCELL_ROW_76_925 VGND VPWR sky130_fd_sc_hd__tapvpwrvgnd_1
XFILLER_1_15 VPWR VGND VPWR VGND sky130_ef_sc_hd__decap_12
XTAP_TAPCELL_ROW_86_1021 VGND VPWR sky130_fd_sc_hd__tapvpwrvgnd_1
XFILLER_18_312 VGND VGND VPWR VPWR sky130_fd_sc_hd__decap_8
XFILLER_18_378 VGND VGND VPWR VPWR sky130_fd_sc_hd__fill_2
XFILLER_33_337 VPWR VGND VPWR VGND sky130_ef_sc_hd__decap_12
XFILLER_45_175 VGND VGND VPWR VPWR sky130_fd_sc_hd__decap_4
XFILLER_60_167 VGND VGND VPWR VPWR sky130_fd_sc_hd__decap_6
X_3570_ _1444_ _1458_ VGND VGND VPWR VPWR _1459_ sky130_fd_sc_hd__xnor2_1
X_2521_ _0492_ _0504_ _0505_ VGND VGND VPWR VPWR _0506_ sky130_fd_sc_hd__and3_1
XFILLER_46_3 VGND VGND VPWR VPWR sky130_fd_sc_hd__decap_6
X_2452_ _0429_ net73 _0417_ _0418_ VGND VGND VPWR VPWR _0437_ sky130_fd_sc_hd__o211a_1
XPHY_EDGE_ROW_18_Right_18 VGND VGND VPWR VPWR sky130_fd_sc_hd__decap_3
X_2383_ _2079_ _2080_ _2078_ VGND VGND VPWR VPWR _2082_ sky130_fd_sc_hd__a21bo_1
X_4122_ net249 VGND VGND VPWR VPWR _0103_ sky130_fd_sc_hd__inv_2
X_4053_ net240 VGND VGND VPWR VPWR _0034_ sky130_fd_sc_hd__inv_2
X_3004_ _0943_ _0954_ VGND VGND VPWR VPWR _0955_ sky130_fd_sc_hd__xnor2_1
Xinput3 D_a_00[2] VGND VGND VPWR VPWR net3 sky130_fd_sc_hd__buf_1
XFILLER_36_153 VGND VGND VPWR VPWR sky130_fd_sc_hd__decap_8
XFILLER_91_281 VPWR VGND VPWR VGND sky130_ef_sc_hd__decap_12
XFILLER_91_270 VGND VGND VPWR VPWR sky130_fd_sc_hd__decap_8
XFILLER_64_473 VGND VGND VPWR VPWR sky130_fd_sc_hd__decap_3
XTAP_TAPCELL_ROW_19_384 VGND VPWR sky130_fd_sc_hd__tapvpwrvgnd_1
XFILLER_24_359 VGND VGND VPWR VPWR sky130_fd_sc_hd__decap_4
XPHY_EDGE_ROW_27_Right_27 VGND VGND VPWR VPWR sky130_fd_sc_hd__decap_3
XFILLER_36_197 VPWR VGND VPWR VGND sky130_ef_sc_hd__decap_12
X_3906_ systolic_unit_0.U_01.acc_0\[13\] net75 net82 systolic_unit_0.U_11.acc_0\[13\]
+ VGND VGND VPWR VPWR _1793_ sky130_fd_sc_hd__a22o_1
X_3837_ net189 net203 _1723_ VGND VGND VPWR VPWR _1726_ sky130_fd_sc_hd__a21oi_1
X_3768_ _1618_ _1619_ VGND VGND VPWR VPWR _1657_ sky130_fd_sc_hd__xnor2_1
X_2719_ net127 net166 _0639_ VGND VGND VPWR VPWR _0672_ sky130_fd_sc_hd__and3_1
XFILLER_3_219 VGND VGND VPWR VPWR sky130_fd_sc_hd__decap_4
X_3699_ _1586_ _1587_ VGND VGND VPWR VPWR _1588_ sky130_fd_sc_hd__nor2_1
XPHY_EDGE_ROW_36_Right_36 VGND VGND VPWR VPWR sky130_fd_sc_hd__decap_3
XFILLER_19_55 VGND VGND VPWR VPWR sky130_fd_sc_hd__fill_1
XFILLER_47_429 VGND VGND VPWR VPWR sky130_fd_sc_hd__decap_8
XFILLER_74_248 VGND VGND VPWR VPWR sky130_fd_sc_hd__decap_4
XFILLER_19_77 VGND VGND VPWR VPWR sky130_fd_sc_hd__decap_6
XFILLER_27_131 VGND VGND VPWR VPWR sky130_fd_sc_hd__fill_1
XFILLER_15_326 VGND VGND VPWR VPWR sky130_fd_sc_hd__decap_8
XFILLER_15_304 VGND VGND VPWR VPWR sky130_fd_sc_hd__decap_6
XPHY_EDGE_ROW_45_Right_45 VGND VGND VPWR VPWR sky130_fd_sc_hd__decap_3
XFILLER_15_337 VPWR VGND VPWR VGND sky130_ef_sc_hd__decap_12
XTAP_TAPCELL_ROW_81_972 VGND VPWR sky130_fd_sc_hd__tapvpwrvgnd_1
XFILLER_30_329 VGND VGND VPWR VPWR sky130_fd_sc_hd__decap_3
XFILLER_7_503 VGND VGND VPWR VPWR sky130_fd_sc_hd__fill_1
XPHY_EDGE_ROW_54_Right_54 VGND VGND VPWR VPWR sky130_fd_sc_hd__decap_3
XTAP_TAPCELL_ROW_92_1080 VGND VPWR sky130_fd_sc_hd__tapvpwrvgnd_1
XFILLER_38_429 VGND VGND VPWR VPWR sky130_fd_sc_hd__fill_1
XPHY_EDGE_ROW_63_Right_63 VGND VGND VPWR VPWR sky130_fd_sc_hd__decap_3
XFILLER_18_153 VPWR VGND VPWR VGND sky130_ef_sc_hd__decap_12
XFILLER_18_197 VGND VGND VPWR VPWR sky130_fd_sc_hd__decap_3
XTAP_TAPCELL_ROW_16_354 VGND VPWR sky130_fd_sc_hd__tapvpwrvgnd_1
X_3622_ _1503_ _1504_ VGND VGND VPWR VPWR _1511_ sky130_fd_sc_hd__xor2_1
XPHY_EDGE_ROW_72_Right_72 VGND VGND VPWR VPWR sky130_fd_sc_hd__decap_3
X_3553_ _1432_ _1436_ _1441_ VGND VGND VPWR VPWR _1442_ sky130_fd_sc_hd__o21a_1
X_3484_ _1313_ _1318_ _1322_ VGND VGND VPWR VPWR _1392_ sky130_fd_sc_hd__a21oi_1
X_2504_ _0483_ _0484_ _0478_ VGND VGND VPWR VPWR _0489_ sky130_fd_sc_hd__o21ai_1
X_2435_ _2118_ _2120_ _2119_ VGND VGND VPWR VPWR _0420_ sky130_fd_sc_hd__a21o_1
XFILLER_84_513 VPWR VGND VPWR VGND sky130_ef_sc_hd__decap_12
X_4105_ net249 VGND VGND VPWR VPWR _0086_ sky130_fd_sc_hd__inv_2
X_2366_ _2058_ _2063_ VGND VGND VPWR VPWR _2065_ sky130_fd_sc_hd__xnor2_1
XPHY_EDGE_ROW_81_Right_81 VGND VGND VPWR VPWR sky130_fd_sc_hd__decap_3
X_2297_ _1978_ _1991_ _1994_ VGND VGND VPWR VPWR _1996_ sky130_fd_sc_hd__and3_1
X_4036_ net246 VGND VGND VPWR VPWR _0017_ sky130_fd_sc_hd__inv_2
XFILLER_52_421 VGND VGND VPWR VPWR sky130_fd_sc_hd__fill_1
XFILLER_12_329 VPWR VGND VPWR VGND sky130_ef_sc_hd__decap_12
XPHY_EDGE_ROW_90_Right_90 VGND VGND VPWR VPWR sky130_fd_sc_hd__decap_3
XFILLER_20_384 VPWR VGND VPWR VGND sky130_ef_sc_hd__decap_12
XTAP_TAPCELL_ROW_50_677 VGND VPWR sky130_fd_sc_hd__tapvpwrvgnd_1
XFILLER_21_23 VGND VGND VPWR VPWR sky130_fd_sc_hd__fill_1
XFILLER_79_329 VGND VGND VPWR VPWR sky130_fd_sc_hd__decap_3
XFILLER_47_204 VPWR VGND VPWR VGND sky130_ef_sc_hd__decap_12
XTAP_TAPCELL_ROW_58_755 VGND VPWR sky130_fd_sc_hd__tapvpwrvgnd_1
XFILLER_28_462 VGND VGND VPWR VPWR sky130_fd_sc_hd__decap_6
XFILLER_55_292 VGND VGND VPWR VPWR sky130_fd_sc_hd__fill_1
Xmax_cap87 _0455_ VGND VGND VPWR VPWR net87 sky130_fd_sc_hd__clkbuf_1
XFILLER_70_273 VGND VGND VPWR VPWR sky130_fd_sc_hd__decap_8
XTAP_TAPCELL_ROW_13_324 VGND VPWR sky130_fd_sc_hd__tapvpwrvgnd_1
XFILLER_62_41 VGND VGND VPWR VPWR sky130_fd_sc_hd__decap_8
XFILLER_62_85 VPWR VGND VPWR VGND sky130_ef_sc_hd__decap_12
XFILLER_7_333 VGND VGND VPWR VPWR sky130_fd_sc_hd__decap_3
XFILLER_7_69 VPWR VGND VPWR VGND sky130_ef_sc_hd__decap_12
X_2220_ _1905_ _1907_ _1911_ VGND VGND VPWR VPWR _1919_ sky130_fd_sc_hd__or3_1
XFILLER_87_93 VPWR VGND VPWR VGND sky130_ef_sc_hd__decap_12
XFILLER_78_351 VPWR VGND VPWR VGND sky130_ef_sc_hd__decap_12
XFILLER_93_321 VGND VGND VPWR VPWR sky130_fd_sc_hd__decap_4
X_2151_ net333 _1875_ net90 VGND VGND VPWR VPWR _0410_ sky130_fd_sc_hd__mux2_1
XFILLER_38_237 VGND VGND VPWR VPWR sky130_fd_sc_hd__fill_1
XFILLER_93_365 VPWR VGND VPWR VGND sky130_ef_sc_hd__decap_12
XFILLER_93_343 VPWR VGND VPWR VGND sky130_ef_sc_hd__decap_12
XFILLER_81_505 VPWR VGND VPWR VGND sky130_ef_sc_hd__decap_12
XFILLER_19_495 VGND VGND VPWR VPWR sky130_fd_sc_hd__decap_8
X_2984_ _0926_ _0932_ _0933_ _0935_ _0736_ VGND VGND VPWR VPWR _0937_ sky130_fd_sc_hd__a2111o_1
XFILLER_21_137 VPWR VGND VPWR VGND sky130_ef_sc_hd__decap_12
X_3605_ _1492_ _1493_ VGND VGND VPWR VPWR _1494_ sky130_fd_sc_hd__and2b_1
X_3536_ systolic_unit_0.U_01.out_b\[6\] net191 net179 net193 VGND VGND VPWR VPWR _1425_
+ sky130_fd_sc_hd__a22o_1
X_3467_ _1377_ _1379_ net133 VGND VGND VPWR VPWR _0312_ sky130_fd_sc_hd__mux2_1
X_3398_ _1305_ _1306_ _1307_ VGND VGND VPWR VPWR _1319_ sky130_fd_sc_hd__a21oi_1
X_2418_ net268 net221 _2078_ _2080_ VGND VGND VPWR VPWR _2117_ sky130_fd_sc_hd__a22o_1
X_2349_ _2046_ _2047_ VGND VGND VPWR VPWR _2048_ sky130_fd_sc_hd__nand2_1
XFILLER_84_365 VGND VGND VPWR VPWR sky130_fd_sc_hd__decap_4
X_4019_ _1850_ _1863_ _1864_ VGND VGND VPWR VPWR _0272_ sky130_fd_sc_hd__and3_1
XTAP_TAPCELL_ROW_55_725 VGND VPWR sky130_fd_sc_hd__tapvpwrvgnd_1
XFILLER_25_432 VGND VGND VPWR VPWR sky130_fd_sc_hd__fill_2
XPHY_EDGE_ROW_0_Right_0 VGND VGND VPWR VPWR sky130_fd_sc_hd__decap_3
XFILLER_25_487 VGND VGND VPWR VPWR sky130_fd_sc_hd__decap_8
XFILLER_52_295 VGND VGND VPWR VPWR sky130_fd_sc_hd__fill_1
XFILLER_0_553 VGND VGND VPWR VPWR sky130_fd_sc_hd__fill_1
XFILLER_87_181 VPWR VGND VPWR VGND sky130_ef_sc_hd__decap_12
XFILLER_75_387 VGND VGND VPWR VPWR sky130_fd_sc_hd__decap_4
XFILLER_16_421 VPWR VGND VPWR VGND sky130_ef_sc_hd__decap_12
XPHY_EDGE_ROW_35_Left_129 VGND VGND VPWR VPWR sky130_fd_sc_hd__decap_3
XFILLER_73_84 VPWR VGND VPWR VGND sky130_ef_sc_hd__decap_12
XFILLER_11_181 VPWR VGND VPWR VGND sky130_ef_sc_hd__decap_12
XFILLER_7_152 VGND VGND VPWR VPWR sky130_fd_sc_hd__fill_1
XPHY_EDGE_ROW_44_Left_138 VGND VGND VPWR VPWR sky130_fd_sc_hd__decap_3
Xhold108 systolic_unit_0.U_01.acc_0\[2\] VGND VGND VPWR VPWR net383 sky130_fd_sc_hd__dlygate4sd3_1
Xhold119 systolic_unit_0.U_01.acc_0\[1\] VGND VGND VPWR VPWR net394 sky130_fd_sc_hd__dlygate4sd3_1
X_4370_ clknet_leaf_12_clk _0343_ _0094_ VGND VGND VPWR VPWR systolic_unit_0.U_01.acc_0\[6\]
+ sky130_fd_sc_hd__dfrtp_1
X_3321_ _1221_ _1241_ VGND VGND VPWR VPWR _1242_ sky130_fd_sc_hd__nor2_1
X_3252_ _1129_ _1172_ VGND VGND VPWR VPWR _1173_ sky130_fd_sc_hd__nor2_1
XFILLER_3_391 VGND VGND VPWR VPWR sky130_fd_sc_hd__fill_1
X_3183_ _1066_ _1068_ _1067_ VGND VGND VPWR VPWR _1104_ sky130_fd_sc_hd__a21o_1
X_2203_ systolic_unit_0.U_00.acc_1\[13\] systolic_unit_0.U_00.acc_0\[13\] net209 VGND
+ VGND VPWR VPWR _1902_ sky130_fd_sc_hd__mux2_1
X_2134_ net148 VGND VGND VPWR VPWR _1867_ sky130_fd_sc_hd__inv_2
XFILLER_81_302 VPWR VGND VPWR VGND sky130_ef_sc_hd__decap_12
XPHY_EDGE_ROW_53_Left_147 VGND VGND VPWR VPWR sky130_fd_sc_hd__decap_3
XFILLER_66_365 VGND VGND VPWR VPWR sky130_fd_sc_hd__decap_8
XFILLER_19_281 VGND VGND VPWR VPWR sky130_fd_sc_hd__decap_8
XFILLER_22_468 VGND VGND VPWR VPWR sky130_fd_sc_hd__decap_8
X_2967_ _0905_ _0906_ VGND VGND VPWR VPWR _0920_ sky130_fd_sc_hd__xnor2_1
XTAP_TAPCELL_ROW_60_772 VGND VPWR sky130_fd_sc_hd__tapvpwrvgnd_1
X_2898_ net128 net173 _0850_ _0848_ VGND VGND VPWR VPWR _0851_ sky130_fd_sc_hd__a31o_1
XPHY_EDGE_ROW_62_Left_156 VGND VGND VPWR VPWR sky130_fd_sc_hd__decap_3
XFILLER_78_29 VPWR VGND VPWR VGND sky130_ef_sc_hd__decap_12
X_3519_ net132 _1380_ VGND VGND VPWR VPWR _1415_ sky130_fd_sc_hd__nor2_1
X_4499_ clknet_leaf_3_clk net293 _0223_ VGND VGND VPWR VPWR systolic_unit_0.out_acc_0_r1\[14\]
+ sky130_fd_sc_hd__dfrtp_1
XFILLER_89_468 VPWR VGND VPWR VGND sky130_ef_sc_hd__decap_12
XFILLER_57_310 VPWR VGND VPWR VGND sky130_ef_sc_hd__decap_12
XPHY_EDGE_ROW_71_Left_165 VGND VGND VPWR VPWR sky130_fd_sc_hd__decap_3
XTAP_TAPCELL_ROW_68_850 VGND VPWR sky130_fd_sc_hd__tapvpwrvgnd_1
XFILLER_17_207 VPWR VGND VPWR VGND sky130_ef_sc_hd__decap_12
XFILLER_45_505 VPWR VGND VPWR VGND sky130_ef_sc_hd__decap_12
XFILLER_84_195 VGND VGND VPWR VPWR sky130_fd_sc_hd__fill_1
XFILLER_27_55 VGND VGND VPWR VPWR sky130_fd_sc_hd__fill_1
XFILLER_27_66 VPWR VGND VPWR VGND sky130_ef_sc_hd__decap_12
XFILLER_45_538 VGND VGND VPWR VPWR sky130_fd_sc_hd__decap_8
XFILLER_9_417 VPWR VGND VPWR VGND sky130_ef_sc_hd__decap_12
XFILLER_25_295 VGND VGND VPWR VPWR sky130_fd_sc_hd__fill_1
XPHY_EDGE_ROW_80_Left_174 VGND VGND VPWR VPWR sky130_fd_sc_hd__decap_3
XFILLER_40_276 VPWR VGND VPWR VGND sky130_ef_sc_hd__decap_12
Xclkbuf_leaf_20_clk clknet_2_3__leaf_clk VGND VGND VPWR VPWR clknet_leaf_20_clk sky130_fd_sc_hd__clkbuf_8
XFILLER_4_15 VPWR VGND VPWR VGND sky130_ef_sc_hd__decap_12
XFILLER_4_177 VGND VGND VPWR VPWR sky130_fd_sc_hd__fill_2
XFILLER_68_51 VPWR VGND VPWR VGND sky130_ef_sc_hd__decap_12
XFILLER_48_365 VPWR VGND VPWR VGND sky130_ef_sc_hd__decap_12
XFILLER_90_121 VPWR VGND VPWR VGND sky130_ef_sc_hd__decap_12
XFILLER_84_83 VGND VGND VPWR VPWR sky130_fd_sc_hd__fill_1
XFILLER_90_165 VPWR VGND VPWR VGND sky130_ef_sc_hd__decap_12
XFILLER_16_240 VPWR VGND VPWR VGND sky130_ef_sc_hd__decap_12
X_3870_ _1702_ _1753_ _1756_ _1758_ VGND VGND VPWR VPWR _1759_ sky130_fd_sc_hd__o31a_1
X_2821_ _0773_ _0772_ VGND VGND VPWR VPWR _0774_ sky130_fd_sc_hd__nand2b_1
XFILLER_76_3 VGND VGND VPWR VPWR sky130_fd_sc_hd__fill_1
X_2752_ net131 net165 VGND VGND VPWR VPWR _0705_ sky130_fd_sc_hd__nand2_1
Xclkbuf_leaf_11_clk clknet_2_2__leaf_clk VGND VGND VPWR VPWR clknet_leaf_11_clk sky130_fd_sc_hd__clkbuf_8
X_2683_ net123 net166 _0614_ VGND VGND VPWR VPWR _0636_ sky130_fd_sc_hd__a21oi_1
X_4422_ clknet_leaf_9_clk net255 _0146_ VGND VGND VPWR VPWR systolic_unit_0.U_00.out_a\[2\]
+ sky130_fd_sc_hd__dfrtp_1
X_4353_ clknet_leaf_12_clk _0326_ _0077_ VGND VGND VPWR VPWR systolic_unit_0.U_01.acc_1\[5\]
+ sky130_fd_sc_hd__dfrtp_1
X_3304_ _1217_ _1218_ _1222_ _1223_ VGND VGND VPWR VPWR _1225_ sky130_fd_sc_hd__a22o_1
X_4284_ clknet_leaf_27_clk _0265_ VGND VGND VPWR VPWR drain_even sky130_fd_sc_hd__dfxtp_1
X_3235_ _1140_ _1155_ _1120_ _1126_ VGND VGND VPWR VPWR _1156_ sky130_fd_sc_hd__a211oi_2
X_3166_ _1085_ _1086_ _1080_ VGND VGND VPWR VPWR _1087_ sky130_fd_sc_hd__a21o_1
XFILLER_39_376 VPWR VGND VPWR VGND sky130_ef_sc_hd__decap_12
X_3097_ _1017_ _1013_ VGND VGND VPWR VPWR _1018_ sky130_fd_sc_hd__and2b_1
XTAP_TAPCELL_ROW_65_820 VGND VPWR sky130_fd_sc_hd__tapvpwrvgnd_1
XFILLER_66_195 VGND VGND VPWR VPWR sky130_fd_sc_hd__fill_1
XTAP_TAPCELL_ROW_37_555 VGND VPWR sky130_fd_sc_hd__tapvpwrvgnd_1
XFILLER_80_19 VGND VGND VPWR VPWR sky130_fd_sc_hd__fill_1
XFILLER_50_541 VGND VGND VPWR VPWR sky130_fd_sc_hd__fill_1
X_3999_ _1865_ _1848_ VGND VGND VPWR VPWR _1851_ sky130_fd_sc_hd__nand2_1
XFILLER_89_39 VPWR VGND VPWR VGND sky130_ef_sc_hd__decap_12
XFILLER_1_125 VPWR VGND VPWR VGND sky130_ef_sc_hd__decap_12
XFILLER_1_169 VPWR VGND VPWR VGND sky130_ef_sc_hd__decap_12
XFILLER_77_449 VPWR VGND VPWR VGND sky130_ef_sc_hd__decap_12
XFILLER_92_419 VGND VGND VPWR VPWR sky130_fd_sc_hd__fill_1
XFILLER_85_493 VGND VGND VPWR VPWR sky130_fd_sc_hd__decap_8
XFILLER_72_121 VPWR VGND VPWR VGND sky130_ef_sc_hd__decap_12
XFILLER_57_184 VGND VGND VPWR VPWR sky130_fd_sc_hd__decap_8
XFILLER_72_154 VGND VGND VPWR VPWR sky130_fd_sc_hd__fill_2
XFILLER_45_357 VGND VGND VPWR VPWR sky130_fd_sc_hd__decap_3
XFILLER_54_53 VGND VGND VPWR VPWR sky130_fd_sc_hd__decap_4
XTAP_TAPCELL_ROW_0_191 VGND VPWR sky130_fd_sc_hd__tapvpwrvgnd_1
XTAP_TAPCELL_ROW_71_878 VGND VPWR sky130_fd_sc_hd__tapvpwrvgnd_1
XFILLER_9_225 VPWR VGND VPWR VGND sky130_ef_sc_hd__decap_12
XFILLER_70_41 VGND VGND VPWR VPWR sky130_fd_sc_hd__decap_6
Xclkload17 clknet_leaf_7_clk VGND VGND VPWR VPWR clkload17/Y sky130_fd_sc_hd__inv_6
XFILLER_70_85 VGND VGND VPWR VPWR sky130_fd_sc_hd__decap_8
Xclkload28 clknet_leaf_20_clk VGND VGND VPWR VPWR clkload28/Y sky130_fd_sc_hd__clkinv_8
XFILLER_5_497 VGND VGND VPWR VPWR sky130_fd_sc_hd__decap_6
XFILLER_68_405 VPWR VGND VPWR VGND sky130_ef_sc_hd__decap_12
XTAP_TAPCELL_ROW_8_280 VGND VPWR sky130_fd_sc_hd__tapvpwrvgnd_1
XTAP_TAPCELL_ROW_79_956 VGND VPWR sky130_fd_sc_hd__tapvpwrvgnd_1
X_3020_ _0923_ _0925_ VGND VGND VPWR VPWR _0965_ sky130_fd_sc_hd__xnor2_1
Xclkbuf_leaf_0_clk clknet_2_0__leaf_clk VGND VGND VPWR VPWR clknet_leaf_0_clk sky130_fd_sc_hd__clkbuf_8
XFILLER_36_313 VGND VGND VPWR VPWR sky130_fd_sc_hd__fill_1
XFILLER_63_143 VPWR VGND VPWR VGND sky130_ef_sc_hd__decap_12
XFILLER_91_485 VPWR VGND VPWR VGND sky130_ef_sc_hd__decap_12
XTAP_TAPCELL_ROW_34_525 VGND VPWR sky130_fd_sc_hd__tapvpwrvgnd_1
XFILLER_51_305 VGND VGND VPWR VPWR sky130_fd_sc_hd__fill_1
XFILLER_63_187 VGND VGND VPWR VPWR sky130_fd_sc_hd__fill_1
XFILLER_32_530 VGND VGND VPWR VPWR sky130_fd_sc_hd__fill_2
X_3922_ systolic_unit_0.U_01.acc_0\[9\] _1785_ _1788_ net406 _1804_ VGND VGND VPWR
+ VPWR _0282_ sky130_fd_sc_hd__o221a_1
X_3853_ net204 net186 _1730_ VGND VGND VPWR VPWR _1742_ sky130_fd_sc_hd__a21oi_1
X_2804_ _0741_ _0756_ VGND VGND VPWR VPWR _0757_ sky130_fd_sc_hd__nor2_1
X_3784_ systolic_unit_0.U_11.acc_1\[3\] systolic_unit_0.U_11.acc_0\[3\] net144 VGND
+ VGND VPWR VPWR _1673_ sky130_fd_sc_hd__mux2_1
X_2735_ _0686_ _0687_ VGND VGND VPWR VPWR _0688_ sky130_fd_sc_hd__nor2_1
X_2666_ net167 net117 _0598_ VGND VGND VPWR VPWR _0619_ sky130_fd_sc_hd__a21oi_1
X_4405_ clknet_leaf_4_clk _0370_ _0129_ VGND VGND VPWR VPWR systolic_unit_0.U_00.acc_0\[1\]
+ sky130_fd_sc_hd__dfrtp_1
Xfanout204 net205 VGND VGND VPWR VPWR net204 sky130_fd_sc_hd__buf_2
X_4336_ clknet_leaf_1_clk _0317_ _0060_ VGND VGND VPWR VPWR systolic_unit_0.U_10.acc_0\[12\]
+ sky130_fd_sc_hd__dfrtp_1
X_2597_ _0524_ _0529_ _0528_ VGND VGND VPWR VPWR _0576_ sky130_fd_sc_hd__a21oi_1
Xfanout215 net7 VGND VGND VPWR VPWR net215 sky130_fd_sc_hd__clkbuf_2
Xfanout237 net239 VGND VGND VPWR VPWR net237 sky130_fd_sc_hd__buf_4
Xfanout226 net253 VGND VGND VPWR VPWR net226 sky130_fd_sc_hd__buf_2
X_4267_ clknet_leaf_19_clk _0248_ _0003_ VGND VGND VPWR VPWR systolic_unit_0.U_11.acc_1\[3\]
+ sky130_fd_sc_hd__dfrtp_1
Xfanout248 net252 VGND VGND VPWR VPWR net248 sky130_fd_sc_hd__buf_4
Xfanout259 net23 VGND VGND VPWR VPWR net259 sky130_fd_sc_hd__clkbuf_2
X_4198_ net237 VGND VGND VPWR VPWR _0179_ sky130_fd_sc_hd__inv_2
X_3218_ _1136_ _1137_ _1131_ VGND VGND VPWR VPWR _1139_ sky130_fd_sc_hd__a21bo_1
X_3149_ _1067_ _1068_ _1066_ VGND VGND VPWR VPWR _1070_ sky130_fd_sc_hd__a21bo_1
XFILLER_82_463 VGND VGND VPWR VPWR sky130_fd_sc_hd__fill_1
XFILLER_27_357 VPWR VGND VPWR VGND sky130_ef_sc_hd__decap_12
XFILLER_23_541 VPWR VGND VPWR VGND sky130_ef_sc_hd__decap_12
XFILLER_40_33 VGND VGND VPWR VPWR sky130_fd_sc_hd__fill_1
XFILLER_6_3 VPWR VGND VPWR VGND sky130_ef_sc_hd__decap_12
XFILLER_2_445 VPWR VGND VPWR VGND sky130_ef_sc_hd__decap_12
XFILLER_2_489 VPWR VGND VPWR VGND sky130_ef_sc_hd__decap_12
XTAP_TAPCELL_ROW_76_926 VGND VPWR sky130_fd_sc_hd__tapvpwrvgnd_1
XTAP_TAPCELL_ROW_5_250 VGND VPWR sky130_fd_sc_hd__tapvpwrvgnd_1
XFILLER_1_27 VPWR VGND VPWR VGND sky130_ef_sc_hd__decap_12
XFILLER_65_30 VGND VGND VPWR VPWR sky130_fd_sc_hd__decap_8
XTAP_TAPCELL_ROW_86_1022 VGND VPWR sky130_fd_sc_hd__tapvpwrvgnd_1
XFILLER_26_390 VGND VGND VPWR VPWR sky130_fd_sc_hd__fill_1
XFILLER_33_349 VPWR VGND VPWR VGND sky130_ef_sc_hd__decap_12
XFILLER_41_393 VGND VGND VPWR VPWR sky130_fd_sc_hd__decap_6
X_2520_ systolic_unit_0.U_00.acc_1\[1\] systolic_unit_0.U_00.acc_0\[1\] net211 VGND
+ VGND VPWR VPWR _0505_ sky130_fd_sc_hd__mux2_1
XFILLER_60_6 VGND VGND VPWR VPWR sky130_fd_sc_hd__decap_4
XFILLER_5_261 VPWR VGND VPWR VGND sky130_ef_sc_hd__decap_12
X_2451_ _0429_ _0434_ _0435_ VGND VGND VPWR VPWR _0436_ sky130_fd_sc_hd__nor3_2
XFILLER_39_3 VGND VGND VPWR VPWR sky130_fd_sc_hd__fill_1
X_2382_ _2078_ _2079_ _2080_ VGND VGND VPWR VPWR _2081_ sky130_fd_sc_hd__nand3_1
X_4121_ net249 VGND VGND VPWR VPWR _0102_ sky130_fd_sc_hd__inv_2
XFILLER_83_205 VPWR VGND VPWR VGND sky130_ef_sc_hd__decap_12
X_4052_ net228 VGND VGND VPWR VPWR _0033_ sky130_fd_sc_hd__inv_2
XFILLER_56_419 VGND VGND VPWR VPWR sky130_fd_sc_hd__fill_1
X_3003_ _0698_ _0938_ _0696_ VGND VGND VPWR VPWR _0954_ sky130_fd_sc_hd__a21o_1
Xinput4 D_a_00[3] VGND VGND VPWR VPWR net4 sky130_fd_sc_hd__buf_1
Xclkbuf_2_1__f_clk clknet_0_clk VGND VGND VPWR VPWR clknet_2_1__leaf_clk sky130_fd_sc_hd__clkbuf_16
XTAP_TAPCELL_ROW_47_650 VGND VPWR sky130_fd_sc_hd__tapvpwrvgnd_1
XFILLER_91_293 VPWR VGND VPWR VGND sky130_ef_sc_hd__decap_12
XTAP_TAPCELL_ROW_19_385 VGND VPWR sky130_fd_sc_hd__tapvpwrvgnd_1
XFILLER_51_113 VGND VGND VPWR VPWR sky130_fd_sc_hd__fill_1
X_3905_ _1775_ _1791_ VGND VGND VPWR VPWR _1792_ sky130_fd_sc_hd__xor2_1
XFILLER_51_157 VGND VGND VPWR VPWR sky130_fd_sc_hd__fill_1
XFILLER_20_533 VPWR VGND VPWR VGND sky130_ef_sc_hd__decap_12
X_3836_ net205 net188 VGND VGND VPWR VPWR _1725_ sky130_fd_sc_hd__nand2_1
X_3767_ _1626_ _1627_ VGND VGND VPWR VPWR _1656_ sky130_fd_sc_hd__xnor2_2
X_2718_ _0669_ _0670_ VGND VGND VPWR VPWR _0671_ sky130_fd_sc_hd__and2_1
X_3698_ net183 net196 net195 net185 VGND VGND VPWR VPWR _1587_ sky130_fd_sc_hd__a22oi_1
X_2649_ systolic_unit_0.U_01.acc_1\[14\] systolic_unit_0.U_01.acc_0\[14\] net139 VGND
+ VGND VPWR VPWR _0602_ sky130_fd_sc_hd__mux2_1
XFILLER_86_29 VPWR VGND VPWR VGND sky130_ef_sc_hd__decap_12
X_4319_ clknet_leaf_1_clk _0300_ _0043_ VGND VGND VPWR VPWR systolic_unit_0.U_10.acc_1\[11\]
+ sky130_fd_sc_hd__dfrtp_1
XTAP_TAPCELL_ROW_2_220 VGND VPWR sky130_fd_sc_hd__tapvpwrvgnd_1
XFILLER_82_293 VGND VGND VPWR VPWR sky130_fd_sc_hd__decap_8
XFILLER_15_349 VPWR VGND VPWR VGND sky130_ef_sc_hd__decap_12
XTAP_TAPCELL_ROW_81_973 VGND VPWR sky130_fd_sc_hd__tapvpwrvgnd_1
XFILLER_70_477 VPWR VGND VPWR VGND sky130_ef_sc_hd__decap_12
XFILLER_23_382 VGND VGND VPWR VPWR sky130_fd_sc_hd__decap_8
XFILLER_23_393 VGND VGND VPWR VPWR sky130_fd_sc_hd__decap_4
XFILLER_78_533 VPWR VGND VPWR VGND sky130_ef_sc_hd__decap_12
XFILLER_73_271 VGND VGND VPWR VPWR sky130_fd_sc_hd__decap_8
XFILLER_18_165 VPWR VGND VPWR VGND sky130_ef_sc_hd__decap_12
XFILLER_46_485 VGND VGND VPWR VPWR sky130_fd_sc_hd__fill_2
XFILLER_33_113 VGND VGND VPWR VPWR sky130_fd_sc_hd__decap_8
XTAP_TAPCELL_ROW_44_620 VGND VPWR sky130_fd_sc_hd__tapvpwrvgnd_1
XFILLER_61_444 VGND VGND VPWR VPWR sky130_fd_sc_hd__decap_4
XFILLER_92_83 VGND VGND VPWR VPWR sky130_fd_sc_hd__fill_1
XTAP_TAPCELL_ROW_16_355 VGND VPWR sky130_fd_sc_hd__tapvpwrvgnd_1
XFILLER_33_146 VPWR VGND VPWR VGND sky130_ef_sc_hd__decap_12
X_3621_ _1508_ _1509_ VGND VGND VPWR VPWR _1510_ sky130_fd_sc_hd__nor2_1
X_3552_ _1432_ _1440_ VGND VGND VPWR VPWR _1441_ sky130_fd_sc_hd__nand2_1
X_2503_ _0464_ _0469_ _0486_ VGND VGND VPWR VPWR _0488_ sky130_fd_sc_hd__a21oi_1
X_3483_ net313 _1356_ _1390_ _1391_ VGND VGND VPWR VPWR _0308_ sky130_fd_sc_hd__a22o_1
X_2434_ _2123_ _2126_ _2125_ VGND VGND VPWR VPWR _0419_ sky130_fd_sc_hd__a21o_1
X_2365_ _2058_ _2063_ VGND VGND VPWR VPWR _2064_ sky130_fd_sc_hd__nand2_1
X_4104_ net251 VGND VGND VPWR VPWR _0085_ sky130_fd_sc_hd__inv_2
XFILLER_84_525 VGND VGND VPWR VPWR sky130_fd_sc_hd__decap_6
X_2296_ _1991_ _1994_ _1978_ VGND VGND VPWR VPWR _1995_ sky130_fd_sc_hd__a21oi_1
X_4035_ net248 VGND VGND VPWR VPWR _0016_ sky130_fd_sc_hd__inv_2
XFILLER_64_282 VGND VGND VPWR VPWR sky130_fd_sc_hd__fill_1
XFILLER_20_363 VGND VGND VPWR VPWR sky130_fd_sc_hd__fill_1
X_3819_ net190 net201 _1706_ VGND VGND VPWR VPWR _1708_ sky130_fd_sc_hd__and3_1
XTAP_TAPCELL_ROW_50_678 VGND VPWR sky130_fd_sc_hd__tapvpwrvgnd_1
XFILLER_20_396 VGND VGND VPWR VPWR sky130_fd_sc_hd__decap_6
XFILLER_21_57 VPWR VGND VPWR VGND sky130_ef_sc_hd__decap_12
XFILLER_75_503 VGND VGND VPWR VPWR sky130_fd_sc_hd__fill_1
XFILLER_47_216 VGND VGND VPWR VPWR sky130_fd_sc_hd__decap_8
XFILLER_28_441 VGND VGND VPWR VPWR sky130_fd_sc_hd__decap_3
XTAP_TAPCELL_ROW_58_756 VGND VPWR sky130_fd_sc_hd__tapvpwrvgnd_1
XFILLER_15_157 VGND VGND VPWR VPWR sky130_fd_sc_hd__fill_2
XFILLER_30_105 VGND VGND VPWR VPWR sky130_fd_sc_hd__fill_2
XTAP_TAPCELL_ROW_13_325 VGND VPWR sky130_fd_sc_hd__tapvpwrvgnd_1
XFILLER_11_330 VGND VGND VPWR VPWR sky130_fd_sc_hd__decap_6
XFILLER_62_97 VPWR VGND VPWR VGND sky130_ef_sc_hd__decap_12
XFILLER_7_15 VPWR VGND VPWR VGND sky130_ef_sc_hd__decap_12
XFILLER_7_345 VGND VGND VPWR VPWR sky130_fd_sc_hd__fill_1
XFILLER_78_363 VGND VGND VPWR VPWR sky130_fd_sc_hd__fill_1
X_2150_ systolic_unit_0.out_acc_0_r1\[9\] systolic_unit_0.out_acc_1_r1\[9\] net143
+ VGND VGND VPWR VPWR _1875_ sky130_fd_sc_hd__mux2_1
XFILLER_93_355 VGND VGND VPWR VPWR sky130_fd_sc_hd__decap_8
XFILLER_93_377 VGND VGND VPWR VPWR sky130_fd_sc_hd__decap_8
XFILLER_81_517 VPWR VGND VPWR VGND sky130_ef_sc_hd__decap_12
XFILLER_19_463 VGND VGND VPWR VPWR sky130_fd_sc_hd__fill_1
XTAP_TAPCELL_ROW_29_480 VGND VPWR sky130_fd_sc_hd__tapvpwrvgnd_1
XFILLER_34_411 VGND VGND VPWR VPWR sky130_fd_sc_hd__decap_8
XFILLER_34_477 VPWR VGND VPWR VGND sky130_ef_sc_hd__decap_12
X_2983_ _0736_ _0775_ VGND VGND VPWR VPWR _0936_ sky130_fd_sc_hd__nand2b_1
XFILLER_21_149 VGND VGND VPWR VPWR sky130_fd_sc_hd__decap_8
X_3604_ _1483_ _1487_ _1486_ VGND VGND VPWR VPWR _1493_ sky130_fd_sc_hd__a21bo_1
X_3535_ net192 net179 _1422_ VGND VGND VPWR VPWR _1424_ sky130_fd_sc_hd__nand3_1
X_3466_ _1328_ _1378_ VGND VGND VPWR VPWR _1379_ sky130_fd_sc_hd__xor2_1
X_2417_ _2083_ _2089_ _2088_ VGND VGND VPWR VPWR _2116_ sky130_fd_sc_hd__a21o_1
XFILLER_69_341 VPWR VGND VPWR VGND sky130_ef_sc_hd__decap_12
X_3397_ _1311_ _1312_ _1268_ VGND VGND VPWR VPWR _1318_ sky130_fd_sc_hd__a21bo_1
XFILLER_69_396 VPWR VGND VPWR VGND sky130_ef_sc_hd__decap_12
X_2348_ net271 net214 net213 net273 VGND VGND VPWR VPWR _2047_ sky130_fd_sc_hd__a22o_1
X_2279_ _1962_ _1976_ VGND VGND VPWR VPWR _1978_ sky130_fd_sc_hd__xnor2_1
XFILLER_29_249 VGND VGND VPWR VPWR sky130_fd_sc_hd__fill_1
X_4018_ row_count\[0\] row_count\[1\] row_count\[2\] VGND VGND VPWR VPWR _1864_ sky130_fd_sc_hd__nand3_1
XTAP_TAPCELL_ROW_55_726 VGND VPWR sky130_fd_sc_hd__tapvpwrvgnd_1
XFILLER_57_53 VGND VGND VPWR VPWR sky130_fd_sc_hd__decap_3
XFILLER_87_193 VPWR VGND VPWR VGND sky130_ef_sc_hd__decap_12
XFILLER_90_325 VGND VGND VPWR VPWR sky130_fd_sc_hd__fill_1
XFILLER_16_433 VPWR VGND VPWR VGND sky130_ef_sc_hd__decap_12
XFILLER_73_96 VPWR VGND VPWR VGND sky130_ef_sc_hd__decap_12
XFILLER_16_499 VPWR VGND VPWR VGND sky130_ef_sc_hd__decap_12
XFILLER_16_477 VPWR VGND VPWR VGND sky130_ef_sc_hd__decap_12
XTAP_TAPCELL_ROW_26_450 VGND VPWR sky130_fd_sc_hd__tapvpwrvgnd_1
XFILLER_31_414 VGND VGND VPWR VPWR sky130_fd_sc_hd__fill_1
XFILLER_31_447 VGND VGND VPWR VPWR sky130_fd_sc_hd__fill_1
XFILLER_11_193 VPWR VGND VPWR VGND sky130_ef_sc_hd__decap_12
XFILLER_7_175 VPWR VGND VPWR VGND sky130_ef_sc_hd__decap_12
Xhold109 systolic_unit_0.U_00.acc_0\[13\] VGND VGND VPWR VPWR net384 sky130_fd_sc_hd__dlygate4sd3_1
X_3320_ _1211_ _1220_ _1128_ VGND VGND VPWR VPWR _1241_ sky130_fd_sc_hd__o21a_1
X_3251_ net113 net155 net154 net115 VGND VGND VPWR VPWR _1172_ sky130_fd_sc_hd__a22oi_1
X_3182_ _1071_ _1077_ _1076_ VGND VGND VPWR VPWR _1103_ sky130_fd_sc_hd__o21bai_1
XFILLER_21_3 VPWR VGND VPWR VGND sky130_ef_sc_hd__decap_12
XFILLER_39_503 VGND VGND VPWR VPWR sky130_fd_sc_hd__fill_1
X_2202_ net209 net206 VGND VGND VPWR VPWR _1901_ sky130_fd_sc_hd__nor2_1
X_2133_ net210 VGND VGND VPWR VPWR _1866_ sky130_fd_sc_hd__inv_2
XFILLER_93_141 VPWR VGND VPWR VGND sky130_ef_sc_hd__decap_12
XFILLER_81_314 VGND VGND VPWR VPWR sky130_fd_sc_hd__decap_8
X_2966_ _0892_ _0918_ VGND VGND VPWR VPWR _0919_ sky130_fd_sc_hd__nor2_1
XTAP_TAPCELL_ROW_60_773 VGND VPWR sky130_fd_sc_hd__tapvpwrvgnd_1
X_2897_ _0846_ _0847_ VGND VGND VPWR VPWR _0850_ sky130_fd_sc_hd__xnor2_2
XFILLER_8_91 VPWR VGND VPWR VGND sky130_ef_sc_hd__decap_12
X_3518_ net96 _1379_ _1414_ VGND VGND VPWR VPWR _0296_ sky130_fd_sc_hd__a21o_1
X_4498_ clknet_leaf_1_clk net298 _0222_ VGND VGND VPWR VPWR systolic_unit_0.out_acc_0_r1\[13\]
+ sky130_fd_sc_hd__dfrtp_1
X_3449_ _1166_ _1365_ VGND VGND VPWR VPWR _1366_ sky130_fd_sc_hd__xnor2_1
XFILLER_57_300 VGND VGND VPWR VPWR sky130_fd_sc_hd__decap_4
XFILLER_57_322 VGND VGND VPWR VPWR sky130_fd_sc_hd__decap_6
XFILLER_84_141 VPWR VGND VPWR VGND sky130_ef_sc_hd__decap_12
XTAP_TAPCELL_ROW_68_851 VGND VPWR sky130_fd_sc_hd__tapvpwrvgnd_1
XFILLER_17_219 VGND VGND VPWR VPWR sky130_fd_sc_hd__decap_4
XFILLER_45_517 VGND VGND VPWR VPWR sky130_fd_sc_hd__fill_1
XFILLER_57_366 VGND VGND VPWR VPWR sky130_fd_sc_hd__fill_2
XFILLER_72_325 VPWR VGND VPWR VGND sky130_ef_sc_hd__decap_12
XFILLER_27_78 VPWR VGND VPWR VGND sky130_ef_sc_hd__decap_12
XFILLER_25_230 VPWR VGND VPWR VGND sky130_ef_sc_hd__decap_12
XFILLER_60_509 VPWR VGND VPWR VGND sky130_ef_sc_hd__decap_12
XFILLER_43_11 VGND VGND VPWR VPWR sky130_fd_sc_hd__fill_1
XFILLER_80_380 VPWR VGND VPWR VGND sky130_ef_sc_hd__decap_12
XFILLER_13_447 VGND VGND VPWR VPWR sky130_fd_sc_hd__fill_1
XTAP_TAPCELL_ROW_23_420 VGND VPWR sky130_fd_sc_hd__tapvpwrvgnd_1
XFILLER_9_429 VPWR VGND VPWR VGND sky130_ef_sc_hd__decap_12
XFILLER_40_288 VPWR VGND VPWR VGND sky130_ef_sc_hd__decap_12
XFILLER_4_145 VPWR VGND VPWR VGND sky130_ef_sc_hd__decap_12
XFILLER_4_189 VGND VGND VPWR VPWR sky130_fd_sc_hd__fill_1
XFILLER_4_27 VGND VGND VPWR VPWR sky130_fd_sc_hd__fill_1
XFILLER_68_63 VPWR VGND VPWR VGND sky130_ef_sc_hd__decap_12
XFILLER_68_85 VGND VGND VPWR VPWR sky130_fd_sc_hd__decap_8
XFILLER_0_351 VGND VGND VPWR VPWR sky130_fd_sc_hd__fill_2
XFILLER_67_108 VGND VGND VPWR VPWR sky130_fd_sc_hd__decap_4
XFILLER_48_377 VGND VGND VPWR VPWR sky130_fd_sc_hd__decap_4
XFILLER_90_133 VGND VGND VPWR VPWR sky130_fd_sc_hd__decap_6
XFILLER_90_177 VPWR VGND VPWR VGND sky130_ef_sc_hd__decap_12
XFILLER_16_263 VGND VGND VPWR VPWR sky130_fd_sc_hd__decap_4
X_2820_ _0740_ _0770_ VGND VGND VPWR VPWR _0773_ sky130_fd_sc_hd__xor2_1
X_2751_ systolic_unit_0.U_01.acc_1\[7\] systolic_unit_0.U_01.acc_0\[7\] net140 VGND
+ VGND VPWR VPWR _0704_ sky130_fd_sc_hd__mux2_1
X_2682_ _0627_ _0634_ VGND VGND VPWR VPWR _0635_ sky130_fd_sc_hd__or2_1
X_4421_ clknet_leaf_10_clk net267 _0145_ VGND VGND VPWR VPWR systolic_unit_0.U_00.out_a\[1\]
+ sky130_fd_sc_hd__dfrtp_1
X_4352_ clknet_leaf_11_clk _0325_ _0076_ VGND VGND VPWR VPWR systolic_unit_0.U_01.acc_1\[4\]
+ sky130_fd_sc_hd__dfrtp_1
X_3303_ _1217_ _1218_ _1222_ _1223_ VGND VGND VPWR VPWR _1224_ sky130_fd_sc_hd__nand4_2
X_4283_ clknet_leaf_28_clk _0264_ VGND VGND VPWR VPWR drain_odd_d1 sky130_fd_sc_hd__dfxtp_1
X_3234_ _1140_ _1152_ _1153_ VGND VGND VPWR VPWR _1155_ sky130_fd_sc_hd__nand3_1
X_3165_ _1064_ _1079_ VGND VGND VPWR VPWR _1086_ sky130_fd_sc_hd__xnor2_1
XFILLER_66_141 VGND VGND VPWR VPWR sky130_fd_sc_hd__decap_4
XFILLER_81_111 VGND VGND VPWR VPWR sky130_fd_sc_hd__fill_1
X_3096_ _1014_ _1016_ VGND VGND VPWR VPWR _1017_ sky130_fd_sc_hd__nor2_1
XFILLER_39_388 VGND VGND VPWR VPWR sky130_fd_sc_hd__decap_4
XTAP_TAPCELL_ROW_65_821 VGND VPWR sky130_fd_sc_hd__tapvpwrvgnd_1
XTAP_TAPCELL_ROW_37_556 VGND VPWR sky130_fd_sc_hd__tapvpwrvgnd_1
X_3998_ _0000_ out_c_valid VGND VGND VPWR VPWR _1850_ sky130_fd_sc_hd__and2_1
XFILLER_13_25 VGND VGND VPWR VPWR sky130_fd_sc_hd__decap_8
X_2949_ _0893_ _0899_ _0901_ VGND VGND VPWR VPWR _0902_ sky130_fd_sc_hd__a21o_1
XFILLER_13_69 VGND VGND VPWR VPWR sky130_fd_sc_hd__decap_8
XFILLER_1_137 VPWR VGND VPWR VGND sky130_ef_sc_hd__decap_12
XFILLER_89_288 VGND VGND VPWR VPWR sky130_fd_sc_hd__decap_8
XFILLER_18_506 VPWR VGND VPWR VGND sky130_ef_sc_hd__decap_12
XFILLER_60_317 VPWR VGND VPWR VGND sky130_ef_sc_hd__decap_12
XTAP_TAPCELL_ROW_0_192 VGND VPWR sky130_fd_sc_hd__tapvpwrvgnd_1
XTAP_TAPCELL_ROW_71_879 VGND VPWR sky130_fd_sc_hd__tapvpwrvgnd_1
XFILLER_13_255 VGND VGND VPWR VPWR sky130_fd_sc_hd__decap_3
XFILLER_70_53 VGND VGND VPWR VPWR sky130_fd_sc_hd__fill_2
XFILLER_9_237 VGND VGND VPWR VPWR sky130_fd_sc_hd__decap_4
Xclkload18 clknet_leaf_8_clk VGND VGND VPWR VPWR clkload18/Y sky130_fd_sc_hd__clkinv_4
Xclkload29 clknet_leaf_21_clk VGND VGND VPWR VPWR clkload29/Y sky130_fd_sc_hd__clkinv_8
XFILLER_68_428 VPWR VGND VPWR VGND sky130_ef_sc_hd__decap_12
XFILLER_68_417 VGND VGND VPWR VPWR sky130_fd_sc_hd__decap_3
XTAP_TAPCELL_ROW_8_281 VGND VPWR sky130_fd_sc_hd__tapvpwrvgnd_1
XFILLER_0_181 VPWR VGND VPWR VGND sky130_ef_sc_hd__decap_12
XFILLER_48_141 VGND VGND VPWR VPWR sky130_fd_sc_hd__fill_2
XFILLER_63_111 VGND VGND VPWR VPWR sky130_fd_sc_hd__fill_1
XFILLER_63_155 VPWR VGND VPWR VGND sky130_ef_sc_hd__decap_12
XFILLER_91_497 VGND VGND VPWR VPWR sky130_fd_sc_hd__decap_6
XFILLER_51_317 VGND VGND VPWR VPWR sky130_fd_sc_hd__fill_1
XTAP_TAPCELL_ROW_34_526 VGND VPWR sky130_fd_sc_hd__tapvpwrvgnd_1
X_3921_ net98 _1803_ VGND VGND VPWR VPWR _1804_ sky130_fd_sc_hd__or2_1
XFILLER_32_553 VGND VGND VPWR VPWR sky130_fd_sc_hd__fill_1
X_3852_ _1733_ _1740_ VGND VGND VPWR VPWR _1741_ sky130_fd_sc_hd__nand2_1
X_2803_ _0754_ _0755_ _0749_ VGND VGND VPWR VPWR _0756_ sky130_fd_sc_hd__a21boi_1
X_3783_ _1661_ _1662_ VGND VGND VPWR VPWR _1672_ sky130_fd_sc_hd__xnor2_1
X_2734_ _0672_ _0674_ _0685_ VGND VGND VPWR VPWR _0687_ sky130_fd_sc_hd__nor3_1
X_2665_ _0615_ _0616_ VGND VGND VPWR VPWR _0618_ sky130_fd_sc_hd__xnor2_1
X_4404_ clknet_leaf_3_clk _0369_ _0128_ VGND VGND VPWR VPWR systolic_unit_0.U_00.acc_0\[0\]
+ sky130_fd_sc_hd__dfrtp_1
X_2596_ net379 net88 _0575_ net208 VGND VGND VPWR VPWR _0379_ sky130_fd_sc_hd__a22o_1
XFILLER_5_81 VPWR VGND VPWR VGND sky130_ef_sc_hd__decap_12
Xfanout205 systolic_unit_0.U_10.out_a\[0\] VGND VGND VPWR VPWR net205 sky130_fd_sc_hd__clkbuf_2
X_4335_ clknet_leaf_1_clk _0316_ _0059_ VGND VGND VPWR VPWR systolic_unit_0.U_10.acc_0\[11\]
+ sky130_fd_sc_hd__dfrtp_1
Xfanout216 net6 VGND VGND VPWR VPWR net216 sky130_fd_sc_hd__buf_2
Xfanout227 net253 VGND VGND VPWR VPWR net227 sky130_fd_sc_hd__buf_4
Xfanout238 net239 VGND VGND VPWR VPWR net238 sky130_fd_sc_hd__buf_4
X_4266_ clknet_leaf_11_clk _0247_ _0002_ VGND VGND VPWR VPWR systolic_unit_0.U_11.acc_1\[2\]
+ sky130_fd_sc_hd__dfrtp_1
Xfanout249 net252 VGND VGND VPWR VPWR net249 sky130_fd_sc_hd__clkbuf_4
X_4197_ net237 VGND VGND VPWR VPWR _0178_ sky130_fd_sc_hd__inv_2
X_3217_ _1131_ _1136_ _1137_ VGND VGND VPWR VPWR _1138_ sky130_fd_sc_hd__nand3_1
XFILLER_67_461 VPWR VGND VPWR VGND sky130_ef_sc_hd__decap_12
X_3148_ _1066_ _1067_ _1068_ VGND VGND VPWR VPWR _1069_ sky130_fd_sc_hd__nand3_1
XFILLER_27_369 VPWR VGND VPWR VGND sky130_ef_sc_hd__decap_12
XFILLER_54_144 VGND VGND VPWR VPWR sky130_fd_sc_hd__decap_8
X_3079_ _0999_ _0995_ VGND VGND VPWR VPWR _1000_ sky130_fd_sc_hd__and2b_1
XFILLER_54_155 VPWR VGND VPWR VGND sky130_ef_sc_hd__decap_12
XFILLER_23_553 VGND VGND VPWR VPWR sky130_fd_sc_hd__fill_1
XFILLER_24_57 VPWR VGND VPWR VGND sky130_ef_sc_hd__decap_12
XFILLER_6_229 VGND VGND VPWR VPWR sky130_fd_sc_hd__fill_1
XFILLER_2_457 VPWR VGND VPWR VGND sky130_ef_sc_hd__decap_12
XFILLER_49_43 VGND VGND VPWR VPWR sky130_fd_sc_hd__decap_4
XFILLER_49_54 VGND VGND VPWR VPWR sky130_fd_sc_hd__fill_2
XFILLER_77_225 VGND VGND VPWR VPWR sky130_fd_sc_hd__decap_3
XTAP_TAPCELL_ROW_5_251 VGND VPWR sky130_fd_sc_hd__tapvpwrvgnd_1
XTAP_TAPCELL_ROW_76_927 VGND VPWR sky130_fd_sc_hd__tapvpwrvgnd_1
XFILLER_73_420 VPWR VGND VPWR VGND sky130_ef_sc_hd__decap_12
XFILLER_1_39 VPWR VGND VPWR VGND sky130_ef_sc_hd__decap_12
XTAP_TAPCELL_ROW_86_1023 VGND VPWR sky130_fd_sc_hd__tapvpwrvgnd_1
XFILLER_33_306 VPWR VGND VPWR VGND sky130_ef_sc_hd__decap_12
XFILLER_60_103 VGND VGND VPWR VPWR sky130_fd_sc_hd__decap_3
XFILLER_60_136 VGND VGND VPWR VPWR sky130_fd_sc_hd__fill_1
XFILLER_14_553 VGND VGND VPWR VPWR sky130_fd_sc_hd__fill_1
XFILLER_5_273 VGND VGND VPWR VPWR sky130_fd_sc_hd__decap_6
X_2450_ _2127_ _0419_ _0428_ VGND VGND VPWR VPWR _0435_ sky130_fd_sc_hd__a21oi_1
X_2381_ net254 net265 net262 net266 VGND VGND VPWR VPWR _2080_ sky130_fd_sc_hd__a22o_1
X_4120_ net251 VGND VGND VPWR VPWR _0101_ sky130_fd_sc_hd__inv_2
XFILLER_68_269 VGND VGND VPWR VPWR sky130_fd_sc_hd__fill_1
X_4051_ net228 VGND VGND VPWR VPWR _0032_ sky130_fd_sc_hd__inv_2
XFILLER_83_217 VGND VGND VPWR VPWR sky130_fd_sc_hd__decap_6
Xinput5 D_a_00[4] VGND VGND VPWR VPWR net5 sky130_fd_sc_hd__buf_1
X_3002_ net400 net85 _0953_ net139 VGND VGND VPWR VPWR _0351_ sky130_fd_sc_hd__a22o_1
XFILLER_36_122 VGND VGND VPWR VPWR sky130_fd_sc_hd__decap_8
XFILLER_36_166 VGND VGND VPWR VPWR sky130_fd_sc_hd__decap_8
XTAP_TAPCELL_ROW_47_651 VGND VPWR sky130_fd_sc_hd__tapvpwrvgnd_1
XTAP_TAPCELL_ROW_19_386 VGND VPWR sky130_fd_sc_hd__tapvpwrvgnd_1
X_3904_ _1496_ _1497_ VGND VGND VPWR VPWR _1791_ sky130_fd_sc_hd__nor2_1
XFILLER_51_169 VGND VGND VPWR VPWR sky130_fd_sc_hd__fill_2
XFILLER_32_383 VPWR VGND VPWR VGND sky130_ef_sc_hd__decap_12
XFILLER_20_545 VGND VGND VPWR VPWR sky130_fd_sc_hd__decap_8
X_3835_ net189 net203 _1723_ VGND VGND VPWR VPWR _1724_ sky130_fd_sc_hd__and3_1
X_3766_ _1653_ _1654_ VGND VGND VPWR VPWR _1655_ sky130_fd_sc_hd__or2_1
X_2717_ systolic_unit_0.U_01.acc_1\[9\] systolic_unit_0.U_01.acc_0\[9\] net140 VGND
+ VGND VPWR VPWR _0670_ sky130_fd_sc_hd__mux2_1
XFILLER_10_15 VPWR VGND VPWR VGND sky130_ef_sc_hd__decap_12
X_3697_ net185 net183 net196 net195 VGND VGND VPWR VPWR _1586_ sky130_fd_sc_hd__and4_1
X_2648_ _0596_ _0600_ VGND VGND VPWR VPWR _0601_ sky130_fd_sc_hd__nand2b_1
X_2579_ net376 net89 _0563_ net211 VGND VGND VPWR VPWR _0384_ sky130_fd_sc_hd__a22o_1
X_4318_ clknet_leaf_2_clk _0299_ _0042_ VGND VGND VPWR VPWR systolic_unit_0.U_10.acc_1\[10\]
+ sky130_fd_sc_hd__dfrtp_1
XFILLER_59_225 VGND VGND VPWR VPWR sky130_fd_sc_hd__fill_2
X_4249_ net235 VGND VGND VPWR VPWR _0230_ sky130_fd_sc_hd__inv_2
XFILLER_59_269 VGND VGND VPWR VPWR sky130_fd_sc_hd__decap_4
XFILLER_74_239 VGND VGND VPWR VPWR sky130_fd_sc_hd__fill_2
XTAP_TAPCELL_ROW_2_221 VGND VPWR sky130_fd_sc_hd__tapvpwrvgnd_1
XFILLER_82_272 VGND VGND VPWR VPWR sky130_fd_sc_hd__fill_1
XFILLER_70_401 VGND VGND VPWR VPWR sky130_fd_sc_hd__decap_6
XFILLER_70_434 VGND VGND VPWR VPWR sky130_fd_sc_hd__fill_1
XTAP_TAPCELL_ROW_81_974 VGND VPWR sky130_fd_sc_hd__tapvpwrvgnd_1
XFILLER_30_309 VPWR VGND VPWR VGND sky130_ef_sc_hd__decap_12
XFILLER_70_489 VPWR VGND VPWR VGND sky130_ef_sc_hd__decap_12
XFILLER_51_11 VGND VGND VPWR VPWR sky130_fd_sc_hd__fill_2
XFILLER_7_505 VPWR VGND VPWR VGND sky130_ef_sc_hd__decap_12
XTAP_TAPCELL_ROW_92_1071 VGND VPWR sky130_fd_sc_hd__tapvpwrvgnd_1
XFILLER_78_545 VGND VGND VPWR VPWR sky130_fd_sc_hd__decap_8
XFILLER_76_85 VPWR VGND VPWR VGND sky130_ef_sc_hd__decap_12
XFILLER_76_63 VGND VGND VPWR VPWR sky130_fd_sc_hd__fill_1
XFILLER_80_209 VPWR VGND VPWR VGND sky130_ef_sc_hd__decap_12
XFILLER_18_177 VGND VGND VPWR VPWR sky130_fd_sc_hd__decap_4
XTAP_TAPCELL_ROW_44_621 VGND VPWR sky130_fd_sc_hd__tapvpwrvgnd_1
XTAP_TAPCELL_ROW_16_356 VGND VPWR sky130_fd_sc_hd__tapvpwrvgnd_1
XFILLER_21_309 VPWR VGND VPWR VGND sky130_ef_sc_hd__decap_12
XFILLER_33_158 VGND VGND VPWR VPWR sky130_fd_sc_hd__decap_8
X_3620_ systolic_unit_0.U_01.out_b\[4\] net194 _1506_ _1507_ VGND VGND VPWR VPWR _1509_
+ sky130_fd_sc_hd__o2bb2a_1
X_3551_ _1436_ _1439_ VGND VGND VPWR VPWR _1440_ sky130_fd_sc_hd__xnor2_1
X_2502_ _0464_ _0469_ _0486_ VGND VGND VPWR VPWR _0487_ sky130_fd_sc_hd__and3_1
X_3482_ systolic_unit_0.U_00.acc_0\[3\] net207 net141 VGND VGND VPWR VPWR _1391_ sky130_fd_sc_hd__a21o_1
XFILLER_51_3 VGND VGND VPWR VPWR sky130_fd_sc_hd__decap_8
X_2433_ _2129_ _2130_ _2115_ VGND VGND VPWR VPWR _0418_ sky130_fd_sc_hd__a21o_1
X_2364_ _2059_ _2061_ VGND VGND VPWR VPWR _2063_ sky130_fd_sc_hd__xor2_1
X_4103_ net251 VGND VGND VPWR VPWR _0084_ sky130_fd_sc_hd__inv_2
X_2295_ _1992_ _1993_ VGND VGND VPWR VPWR _1994_ sky130_fd_sc_hd__nand2_1
X_4034_ net248 VGND VGND VPWR VPWR _0015_ sky130_fd_sc_hd__inv_2
XFILLER_37_453 VGND VGND VPWR VPWR sky130_fd_sc_hd__fill_2
XFILLER_37_475 VGND VGND VPWR VPWR sky130_fd_sc_hd__decap_8
XFILLER_52_401 VGND VGND VPWR VPWR sky130_fd_sc_hd__fill_1
XFILLER_24_125 VGND VGND VPWR VPWR sky130_fd_sc_hd__decap_8
XFILLER_20_320 VGND VGND VPWR VPWR sky130_fd_sc_hd__decap_3
X_3818_ net190 net201 VGND VGND VPWR VPWR _1707_ sky130_fd_sc_hd__nand2_1
XTAP_TAPCELL_ROW_50_679 VGND VPWR sky130_fd_sc_hd__tapvpwrvgnd_1
XFILLER_21_69 VGND VGND VPWR VPWR sky130_fd_sc_hd__decap_4
X_3749_ _1613_ _1628_ VGND VGND VPWR VPWR _1638_ sky130_fd_sc_hd__xnor2_1
XFILLER_79_309 VGND VGND VPWR VPWR sky130_fd_sc_hd__fill_1
XTAP_TAPCELL_ROW_58_757 VGND VPWR sky130_fd_sc_hd__tapvpwrvgnd_1
XFILLER_62_209 VGND VGND VPWR VPWR sky130_fd_sc_hd__decap_4
XFILLER_70_253 VGND VGND VPWR VPWR sky130_fd_sc_hd__decap_4
XFILLER_70_231 VGND VGND VPWR VPWR sky130_fd_sc_hd__decap_8
XFILLER_43_456 VPWR VGND VPWR VGND sky130_ef_sc_hd__decap_12
XTAP_TAPCELL_ROW_13_326 VGND VPWR sky130_fd_sc_hd__tapvpwrvgnd_1
XFILLER_30_139 VGND VGND VPWR VPWR sky130_fd_sc_hd__fill_1
XFILLER_7_27 VPWR VGND VPWR VGND sky130_ef_sc_hd__decap_12
XFILLER_7_368 VPWR VGND VPWR VGND sky130_ef_sc_hd__decap_12
XFILLER_3_541 VPWR VGND VPWR VGND sky130_ef_sc_hd__decap_12
XFILLER_87_51 VGND VGND VPWR VPWR sky130_fd_sc_hd__decap_4
XFILLER_93_301 VGND VGND VPWR VPWR sky130_fd_sc_hd__decap_6
XFILLER_81_529 VPWR VGND VPWR VGND sky130_ef_sc_hd__decap_12
XFILLER_19_453 VGND VGND VPWR VPWR sky130_fd_sc_hd__fill_1
XFILLER_53_209 VGND VGND VPWR VPWR sky130_fd_sc_hd__fill_1
XTAP_TAPCELL_ROW_29_481 VGND VPWR sky130_fd_sc_hd__tapvpwrvgnd_1
XFILLER_46_294 VPWR VGND VPWR VGND sky130_ef_sc_hd__decap_12
XFILLER_34_467 VGND VGND VPWR VPWR sky130_fd_sc_hd__fill_2
X_2982_ _0737_ _0776_ VGND VGND VPWR VPWR _0935_ sky130_fd_sc_hd__and2b_1
XFILLER_34_489 VGND VGND VPWR VPWR sky130_fd_sc_hd__fill_2
XFILLER_61_275 VGND VGND VPWR VPWR sky130_fd_sc_hd__decap_4
Xinput30 D_b_01[5] VGND VGND VPWR VPWR net30 sky130_fd_sc_hd__clkbuf_1
X_3603_ _1490_ _1491_ VGND VGND VPWR VPWR _1492_ sky130_fd_sc_hd__or2_1
X_3534_ net193 net180 VGND VGND VPWR VPWR _1423_ sky130_fd_sc_hd__nand2_1
X_3465_ _1258_ _1259_ VGND VGND VPWR VPWR _1378_ sky130_fd_sc_hd__nor2_1
XFILLER_88_139 VGND VGND VPWR VPWR sky130_fd_sc_hd__fill_1
X_2416_ _2109_ _2114_ VGND VGND VPWR VPWR _2115_ sky130_fd_sc_hd__xor2_1
XFILLER_69_353 VPWR VGND VPWR VGND sky130_ef_sc_hd__decap_12
X_3396_ _1315_ _1316_ VGND VGND VPWR VPWR _1317_ sky130_fd_sc_hd__and2b_1
XFILLER_57_515 VPWR VGND VPWR VGND sky130_ef_sc_hd__decap_12
X_2347_ net273 net271 net214 net213 VGND VGND VPWR VPWR _2046_ sky130_fd_sc_hd__nand4_1
XFILLER_84_345 VGND VGND VPWR VPWR sky130_fd_sc_hd__fill_1
X_2278_ _1962_ _1976_ VGND VGND VPWR VPWR _1977_ sky130_fd_sc_hd__nand2_1
X_4017_ row_count\[0\] row_count\[1\] row_count\[2\] VGND VGND VPWR VPWR _1863_ sky130_fd_sc_hd__a21o_1
XFILLER_25_412 VPWR VGND VPWR VGND sky130_ef_sc_hd__decap_12
XTAP_TAPCELL_ROW_55_727 VGND VPWR sky130_fd_sc_hd__tapvpwrvgnd_1
XFILLER_52_242 VGND VGND VPWR VPWR sky130_fd_sc_hd__decap_3
XFILLER_52_253 VGND VGND VPWR VPWR sky130_fd_sc_hd__fill_1
XFILLER_12_139 VGND VGND VPWR VPWR sky130_fd_sc_hd__fill_1
XFILLER_79_106 VGND VGND VPWR VPWR sky130_fd_sc_hd__fill_2
XFILLER_79_139 VGND VGND VPWR VPWR sky130_fd_sc_hd__decap_3
XFILLER_0_533 VPWR VGND VPWR VGND sky130_ef_sc_hd__decap_12
XFILLER_87_161 VGND VGND VPWR VPWR sky130_fd_sc_hd__decap_6
XFILLER_57_21 VPWR VGND VPWR VGND sky130_ef_sc_hd__decap_12
XFILLER_75_334 VGND VGND VPWR VPWR sky130_fd_sc_hd__fill_2
XFILLER_48_548 VGND VGND VPWR VPWR sky130_fd_sc_hd__fill_2
XFILLER_57_98 VGND VGND VPWR VPWR sky130_fd_sc_hd__decap_4
XFILLER_73_20 VPWR VGND VPWR VGND sky130_ef_sc_hd__decap_12
XFILLER_16_445 VPWR VGND VPWR VGND sky130_ef_sc_hd__decap_12
XFILLER_16_489 VGND VGND VPWR VPWR sky130_fd_sc_hd__decap_3
XTAP_TAPCELL_ROW_26_451 VGND VPWR sky130_fd_sc_hd__tapvpwrvgnd_1
XFILLER_43_253 VGND VGND VPWR VPWR sky130_fd_sc_hd__fill_1
XFILLER_11_150 VGND VGND VPWR VPWR sky130_fd_sc_hd__fill_1
XFILLER_7_110 VGND VGND VPWR VPWR sky130_fd_sc_hd__fill_2
XFILLER_7_187 VPWR VGND VPWR VGND sky130_ef_sc_hd__decap_12
X_3250_ net160 net107 _1168_ _1169_ VGND VGND VPWR VPWR _1171_ sky130_fd_sc_hd__nand4_1
XFILLER_3_393 VPWR VGND VPWR VGND sky130_ef_sc_hd__decap_12
X_3181_ _1085_ _1086_ VGND VGND VPWR VPWR _1102_ sky130_fd_sc_hd__xnor2_1
X_2201_ net353 _1900_ net91 VGND VGND VPWR VPWR _0385_ sky130_fd_sc_hd__mux2_1
XFILLER_66_312 VGND VGND VPWR VPWR sky130_fd_sc_hd__decap_8
X_2132_ matrix_count\[0\] VGND VGND VPWR VPWR _1865_ sky130_fd_sc_hd__inv_2
XFILLER_93_153 VPWR VGND VPWR VGND sky130_ef_sc_hd__decap_12
XFILLER_93_197 VGND VGND VPWR VPWR sky130_fd_sc_hd__decap_8
XFILLER_81_337 VPWR VGND VPWR VGND sky130_ef_sc_hd__decap_12
XFILLER_34_264 VGND VGND VPWR VPWR sky130_fd_sc_hd__fill_2
XTAP_TAPCELL_ROW_60_774 VGND VPWR sky130_fd_sc_hd__tapvpwrvgnd_1
X_2965_ _0908_ _0917_ VGND VGND VPWR VPWR _0918_ sky130_fd_sc_hd__or2_1
X_2896_ net128 net173 VGND VGND VPWR VPWR _0849_ sky130_fd_sc_hd__nand2_1
X_3517_ systolic_unit_0.U_10.acc_1\[7\] net76 net83 systolic_unit_0.U_00.acc_1\[7\]
+ VGND VGND VPWR VPWR _1414_ sky130_fd_sc_hd__a22o_1
XFILLER_1_308 VGND VGND VPWR VPWR sky130_fd_sc_hd__fill_2
X_4497_ clknet_leaf_1_clk net303 _0221_ VGND VGND VPWR VPWR systolic_unit_0.out_acc_0_r1\[12\]
+ sky130_fd_sc_hd__dfrtp_1
X_3448_ _1160_ _1364_ VGND VGND VPWR VPWR _1365_ sky130_fd_sc_hd__nor2_1
XFILLER_69_161 VGND VGND VPWR VPWR sky130_fd_sc_hd__decap_6
XFILLER_69_150 VGND VGND VPWR VPWR sky130_fd_sc_hd__fill_1
X_3379_ _1285_ _1299_ VGND VGND VPWR VPWR _1300_ sky130_fd_sc_hd__and2_1
XFILLER_84_153 VPWR VGND VPWR VGND sky130_ef_sc_hd__decap_12
XTAP_TAPCELL_ROW_68_852 VGND VPWR sky130_fd_sc_hd__tapvpwrvgnd_1
XFILLER_84_197 VPWR VGND VPWR VGND sky130_ef_sc_hd__decap_12
XFILLER_72_337 VGND VGND VPWR VPWR sky130_fd_sc_hd__decap_4
XFILLER_25_242 VGND VGND VPWR VPWR sky130_fd_sc_hd__fill_2
XFILLER_80_392 VGND VGND VPWR VPWR sky130_fd_sc_hd__decap_8
XTAP_TAPCELL_ROW_23_421 VGND VPWR sky130_fd_sc_hd__tapvpwrvgnd_1
XFILLER_40_212 VGND VGND VPWR VPWR sky130_fd_sc_hd__decap_4
XFILLER_43_89 VGND VGND VPWR VPWR sky130_fd_sc_hd__decap_3
XFILLER_4_157 VPWR VGND VPWR VGND sky130_ef_sc_hd__decap_12
XFILLER_68_20 VGND VGND VPWR VPWR sky130_fd_sc_hd__decap_8
XFILLER_68_75 VGND VGND VPWR VPWR sky130_fd_sc_hd__decap_8
XFILLER_0_363 VGND VGND VPWR VPWR sky130_fd_sc_hd__fill_1
XFILLER_48_301 VGND VGND VPWR VPWR sky130_fd_sc_hd__decap_6
XFILLER_0_385 VGND VGND VPWR VPWR sky130_fd_sc_hd__decap_3
XTAP_TAPCELL_ROW_89_1043 VGND VPWR sky130_fd_sc_hd__tapvpwrvgnd_1
XFILLER_84_41 VPWR VGND VPWR VGND sky130_ef_sc_hd__decap_12
XFILLER_84_85 VPWR VGND VPWR VGND sky130_ef_sc_hd__decap_12
XFILLER_90_189 VGND VGND VPWR VPWR sky130_fd_sc_hd__decap_6
XFILLER_16_297 VGND VGND VPWR VPWR sky130_fd_sc_hd__decap_8
XFILLER_31_223 VGND VGND VPWR VPWR sky130_fd_sc_hd__fill_1
X_2750_ _0669_ _0702_ VGND VGND VPWR VPWR _0703_ sky130_fd_sc_hd__nor2_1
XFILLER_31_278 VGND VGND VPWR VPWR sky130_fd_sc_hd__fill_2
X_2681_ _0618_ _0626_ VGND VGND VPWR VPWR _0634_ sky130_fd_sc_hd__and2_1
X_4420_ clknet_leaf_10_clk net275 _0144_ VGND VGND VPWR VPWR systolic_unit_0.U_00.out_a\[0\]
+ sky130_fd_sc_hd__dfrtp_1
X_4351_ clknet_leaf_12_clk _0324_ _0075_ VGND VGND VPWR VPWR systolic_unit_0.U_01.acc_1\[3\]
+ sky130_fd_sc_hd__dfrtp_1
X_3302_ _1174_ _1219_ _1221_ VGND VGND VPWR VPWR _1223_ sky130_fd_sc_hd__a21o_1
X_4282_ clknet_leaf_27_clk _0263_ VGND VGND VPWR VPWR drain_odd sky130_fd_sc_hd__dfxtp_1
X_3233_ _1140_ _1152_ _1153_ VGND VGND VPWR VPWR _1154_ sky130_fd_sc_hd__and3_1
XFILLER_39_301 VGND VGND VPWR VPWR sky130_fd_sc_hd__decap_4
X_3164_ _1083_ _1084_ VGND VGND VPWR VPWR _1085_ sky130_fd_sc_hd__and2_1
XFILLER_27_518 VPWR VGND VPWR VGND sky130_ef_sc_hd__decap_12
X_3095_ _1014_ _1015_ net155 net105 VGND VGND VPWR VPWR _1016_ sky130_fd_sc_hd__and4bb_1
XTAP_TAPCELL_ROW_65_822 VGND VPWR sky130_fd_sc_hd__tapvpwrvgnd_1
XTAP_TAPCELL_ROW_37_557 VGND VPWR sky130_fd_sc_hd__tapvpwrvgnd_1
X_3997_ _1865_ _1848_ VGND VGND VPWR VPWR _1849_ sky130_fd_sc_hd__nor2_1
X_2948_ net177 net127 _0900_ VGND VGND VPWR VPWR _0901_ sky130_fd_sc_hd__and3_1
X_2879_ _0815_ _0817_ VGND VGND VPWR VPWR _0832_ sky130_fd_sc_hd__xnor2_1
XFILLER_1_105 VGND VGND VPWR VPWR sky130_fd_sc_hd__decap_6
XFILLER_89_223 VGND VGND VPWR VPWR sky130_fd_sc_hd__fill_1
XFILLER_1_149 VGND VGND VPWR VPWR sky130_fd_sc_hd__decap_4
XFILLER_18_518 VPWR VGND VPWR VGND sky130_ef_sc_hd__decap_12
XFILLER_38_89 VGND VGND VPWR VPWR sky130_fd_sc_hd__fill_1
XFILLER_45_337 VPWR VGND VPWR VGND sky130_ef_sc_hd__decap_12
XFILLER_60_329 VGND VGND VPWR VPWR sky130_fd_sc_hd__decap_4
XTAP_TAPCELL_ROW_0_193 VGND VPWR sky130_fd_sc_hd__tapvpwrvgnd_1
XFILLER_70_76 VGND VGND VPWR VPWR sky130_fd_sc_hd__decap_8
Xclkload19 clknet_leaf_9_clk VGND VGND VPWR VPWR clkload19/Y sky130_fd_sc_hd__inv_6
XTAP_TAPCELL_ROW_8_282 VGND VPWR sky130_fd_sc_hd__tapvpwrvgnd_1
XFILLER_0_193 VGND VGND VPWR VPWR sky130_fd_sc_hd__decap_3
XFILLER_76_484 VPWR VGND VPWR VGND sky130_ef_sc_hd__decap_12
XFILLER_48_186 VGND VGND VPWR VPWR sky130_fd_sc_hd__decap_8
XFILLER_48_197 VPWR VGND VPWR VGND sky130_ef_sc_hd__decap_12
X_3920_ _1645_ _1802_ VGND VGND VPWR VPWR _1803_ sky130_fd_sc_hd__xnor2_1
XFILLER_63_167 VGND VGND VPWR VPWR sky130_fd_sc_hd__fill_1
XFILLER_32_510 VPWR VGND VPWR VGND sky130_ef_sc_hd__decap_12
XTAP_TAPCELL_ROW_34_527 VGND VPWR sky130_fd_sc_hd__tapvpwrvgnd_1
X_3851_ _1729_ _1731_ _1732_ VGND VGND VPWR VPWR _1740_ sky130_fd_sc_hd__or3_1
XFILLER_81_3 VPWR VGND VPWR VGND sky130_ef_sc_hd__decap_12
X_2802_ _0742_ _0748_ VGND VGND VPWR VPWR _0755_ sky130_fd_sc_hd__xor2_1
X_3782_ _1665_ _1666_ VGND VGND VPWR VPWR _1671_ sky130_fd_sc_hd__xnor2_1
X_2733_ _0672_ _0674_ _0685_ VGND VGND VPWR VPWR _0686_ sky130_fd_sc_hd__o21a_1
X_2664_ _0615_ _0616_ VGND VGND VPWR VPWR _0617_ sky130_fd_sc_hd__and2_1
X_4403_ clknet_leaf_12_clk net117 _0127_ VGND VGND VPWR VPWR systolic_unit_0.U_01.out_b\[7\]
+ sky130_fd_sc_hd__dfrtp_1
X_2595_ _0570_ _0574_ VGND VGND VPWR VPWR _0575_ sky130_fd_sc_hd__and2_1
X_4334_ clknet_leaf_2_clk _0315_ _0058_ VGND VGND VPWR VPWR systolic_unit_0.U_10.acc_0\[10\]
+ sky130_fd_sc_hd__dfrtp_1
Xfanout217 net6 VGND VGND VPWR VPWR net217 sky130_fd_sc_hd__clkbuf_2
XFILLER_5_93 VGND VGND VPWR VPWR sky130_fd_sc_hd__decap_4
Xfanout228 net231 VGND VGND VPWR VPWR net228 sky130_fd_sc_hd__buf_4
Xfanout206 drain_even VGND VGND VPWR VPWR net206 sky130_fd_sc_hd__clkbuf_4
Xfanout239 net242 VGND VGND VPWR VPWR net239 sky130_fd_sc_hd__buf_2
X_4265_ clknet_leaf_19_clk _0246_ _0001_ VGND VGND VPWR VPWR systolic_unit_0.U_11.acc_1\[1\]
+ sky130_fd_sc_hd__dfrtp_1
X_3216_ _1108_ _1130_ _1129_ VGND VGND VPWR VPWR _1137_ sky130_fd_sc_hd__a21o_1
X_4196_ net237 VGND VGND VPWR VPWR _0177_ sky130_fd_sc_hd__inv_2
XFILLER_39_131 VPWR VGND VPWR VGND sky130_ef_sc_hd__decap_12
XFILLER_67_473 VGND VGND VPWR VPWR sky130_fd_sc_hd__fill_1
X_3147_ net111 net154 net152 net113 VGND VGND VPWR VPWR _1068_ sky130_fd_sc_hd__a22o_1
XFILLER_27_337 VPWR VGND VPWR VGND sky130_ef_sc_hd__decap_12
XFILLER_54_112 VPWR VGND VPWR VGND sky130_ef_sc_hd__decap_12
X_3078_ _0996_ _0998_ VGND VGND VPWR VPWR _0999_ sky130_fd_sc_hd__nor2_1
XFILLER_42_307 VGND VGND VPWR VPWR sky130_fd_sc_hd__fill_1
XFILLER_54_167 VGND VGND VPWR VPWR sky130_fd_sc_hd__decap_8
XPHY_EDGE_ROW_59_Left_153 VGND VGND VPWR VPWR sky130_fd_sc_hd__decap_3
XFILLER_24_69 VPWR VGND VPWR VGND sky130_ef_sc_hd__decap_12
XFILLER_50_362 VGND VGND VPWR VPWR sky130_fd_sc_hd__fill_2
XFILLER_50_373 VGND VGND VPWR VPWR sky130_fd_sc_hd__fill_2
XFILLER_40_57 VGND VGND VPWR VPWR sky130_fd_sc_hd__fill_1
XPHY_EDGE_ROW_68_Left_162 VGND VGND VPWR VPWR sky130_fd_sc_hd__decap_3
XFILLER_2_469 VGND VGND VPWR VPWR sky130_fd_sc_hd__decap_6
XTAP_TAPCELL_ROW_5_252 VGND VPWR sky130_fd_sc_hd__tapvpwrvgnd_1
XTAP_TAPCELL_ROW_76_928 VGND VPWR sky130_fd_sc_hd__tapvpwrvgnd_1
XFILLER_85_281 VPWR VGND VPWR VGND sky130_ef_sc_hd__decap_12
XFILLER_73_432 VGND VGND VPWR VPWR sky130_fd_sc_hd__fill_2
XPHY_EDGE_ROW_77_Left_171 VGND VGND VPWR VPWR sky130_fd_sc_hd__decap_3
XFILLER_33_318 VPWR VGND VPWR VGND sky130_ef_sc_hd__decap_12
XFILLER_45_167 VGND VGND VPWR VPWR sky130_fd_sc_hd__fill_1
XFILLER_14_521 VGND VGND VPWR VPWR sky130_fd_sc_hd__decap_8
XFILLER_81_53 VGND VGND VPWR VPWR sky130_fd_sc_hd__decap_3
XPHY_EDGE_ROW_86_Left_180 VGND VGND VPWR VPWR sky130_fd_sc_hd__decap_3
X_2380_ net268 net221 VGND VGND VPWR VPWR _2079_ sky130_fd_sc_hd__and2_1
X_4050_ net248 VGND VGND VPWR VPWR _0031_ sky130_fd_sc_hd__inv_2
Xinput6 D_a_00[5] VGND VGND VPWR VPWR net6 sky130_fd_sc_hd__buf_1
X_3001_ _0944_ _0952_ VGND VGND VPWR VPWR _0953_ sky130_fd_sc_hd__nor2_1
XFILLER_64_421 VPWR VGND VPWR VGND sky130_ef_sc_hd__decap_12
XFILLER_24_307 VGND VGND VPWR VPWR sky130_fd_sc_hd__fill_1
XTAP_TAPCELL_ROW_47_652 VGND VPWR sky130_fd_sc_hd__tapvpwrvgnd_1
XFILLER_17_381 VGND VGND VPWR VPWR sky130_fd_sc_hd__fill_1
X_3903_ net149 _1789_ _1790_ VGND VGND VPWR VPWR _0287_ sky130_fd_sc_hd__a21o_1
X_3834_ systolic_unit_0.U_11.acc_1\[1\] systolic_unit_0.U_11.acc_0\[1\] net145 VGND
+ VGND VPWR VPWR _1723_ sky130_fd_sc_hd__mux2_1
XFILLER_32_395 VGND VGND VPWR VPWR sky130_fd_sc_hd__fill_1
X_3765_ _1650_ _1652_ VGND VGND VPWR VPWR _1654_ sky130_fd_sc_hd__and2b_1
X_2716_ net128 net165 _0668_ VGND VGND VPWR VPWR _0669_ sky130_fd_sc_hd__and3_1
X_3696_ net198 net182 VGND VGND VPWR VPWR _1585_ sky130_fd_sc_hd__nand2_1
X_2647_ net121 net166 _0592_ _0599_ VGND VGND VPWR VPWR _0600_ sky130_fd_sc_hd__a31o_1
XFILLER_10_27 VGND VGND VPWR VPWR sky130_fd_sc_hd__fill_1
X_2578_ _0557_ _0562_ VGND VGND VPWR VPWR _0563_ sky130_fd_sc_hd__xnor2_1
XFILLER_59_204 VGND VGND VPWR VPWR sky130_fd_sc_hd__fill_2
X_4317_ clknet_leaf_32_clk _0298_ _0041_ VGND VGND VPWR VPWR systolic_unit_0.U_10.acc_1\[9\]
+ sky130_fd_sc_hd__dfrtp_1
X_4248_ net235 VGND VGND VPWR VPWR _0229_ sky130_fd_sc_hd__inv_2
XFILLER_59_248 VGND VGND VPWR VPWR sky130_fd_sc_hd__fill_2
XTAP_TAPCELL_ROW_2_222 VGND VPWR sky130_fd_sc_hd__tapvpwrvgnd_1
X_4179_ net241 VGND VGND VPWR VPWR _0160_ sky130_fd_sc_hd__inv_2
XFILLER_82_240 VGND VGND VPWR VPWR sky130_fd_sc_hd__decap_4
XTAP_TAPCELL_ROW_81_975 VGND VPWR sky130_fd_sc_hd__tapvpwrvgnd_1
XPHY_EDGE_ROW_14_Right_14 VGND VGND VPWR VPWR sky130_fd_sc_hd__decap_3
XFILLER_7_517 VPWR VGND VPWR VGND sky130_ef_sc_hd__decap_12
XTAP_TAPCELL_ROW_92_1072 VGND VPWR sky130_fd_sc_hd__tapvpwrvgnd_1
XPHY_EDGE_ROW_23_Right_23 VGND VGND VPWR VPWR sky130_fd_sc_hd__decap_3
XFILLER_93_505 VPWR VGND VPWR VGND sky130_ef_sc_hd__decap_12
XFILLER_65_229 VGND VGND VPWR VPWR sky130_fd_sc_hd__decap_6
XFILLER_76_97 VGND VGND VPWR VPWR sky130_fd_sc_hd__fill_2
XFILLER_46_421 VPWR VGND VPWR VGND sky130_ef_sc_hd__decap_12
XFILLER_92_41 VPWR VGND VPWR VGND sky130_ef_sc_hd__decap_12
XFILLER_73_295 VGND VGND VPWR VPWR sky130_fd_sc_hd__decap_3
XFILLER_33_104 VGND VGND VPWR VPWR sky130_fd_sc_hd__decap_8
XTAP_TAPCELL_ROW_44_622 VGND VPWR sky130_fd_sc_hd__tapvpwrvgnd_1
XFILLER_92_85 VPWR VGND VPWR VGND sky130_ef_sc_hd__decap_12
XTAP_TAPCELL_ROW_16_357 VGND VPWR sky130_fd_sc_hd__tapvpwrvgnd_1
XFILLER_14_340 VPWR VGND VPWR VGND sky130_ef_sc_hd__decap_12
XPHY_EDGE_ROW_32_Right_32 VGND VGND VPWR VPWR sky130_fd_sc_hd__decap_3
XFILLER_41_192 VGND VGND VPWR VPWR sky130_fd_sc_hd__fill_1
X_3550_ _1437_ _1438_ VGND VGND VPWR VPWR _1439_ sky130_fd_sc_hd__nand2_1
X_2501_ _0478_ _0484_ _0483_ VGND VGND VPWR VPWR _0486_ sky130_fd_sc_hd__o21bai_1
X_3481_ net137 _1389_ VGND VGND VPWR VPWR _1390_ sky130_fd_sc_hd__nand2_1
XPHY_EDGE_ROW_41_Right_41 VGND VGND VPWR VPWR sky130_fd_sc_hd__decap_3
XFILLER_44_3 VPWR VGND VPWR VGND sky130_ef_sc_hd__decap_12
X_2432_ _2115_ _2129_ _2130_ VGND VGND VPWR VPWR _0417_ sky130_fd_sc_hd__nand3_1
X_2363_ _2059_ _2061_ VGND VGND VPWR VPWR _2062_ sky130_fd_sc_hd__or2_1
X_4102_ net249 VGND VGND VPWR VPWR _0083_ sky130_fd_sc_hd__inv_2
X_2294_ _1980_ _1990_ VGND VGND VPWR VPWR _1993_ sky130_fd_sc_hd__xor2_1
X_4033_ net251 VGND VGND VPWR VPWR _0014_ sky130_fd_sc_hd__inv_2
XFILLER_2_83 VGND VGND VPWR VPWR sky130_fd_sc_hd__fill_1
XFILLER_49_281 VGND VGND VPWR VPWR sky130_fd_sc_hd__decap_4
XFILLER_37_465 VGND VGND VPWR VPWR sky130_fd_sc_hd__decap_6
XFILLER_64_251 VGND VGND VPWR VPWR sky130_fd_sc_hd__fill_1
XFILLER_37_487 VGND VGND VPWR VPWR sky130_fd_sc_hd__decap_4
XPHY_EDGE_ROW_50_Right_50 VGND VGND VPWR VPWR sky130_fd_sc_hd__decap_3
X_3817_ systolic_unit_0.U_11.acc_1\[2\] systolic_unit_0.U_11.acc_0\[2\] net144 VGND
+ VGND VPWR VPWR _1706_ sky130_fd_sc_hd__mux2_2
XFILLER_21_15 VGND VGND VPWR VPWR sky130_fd_sc_hd__decap_8
X_3748_ _1631_ _1636_ VGND VGND VPWR VPWR _1637_ sky130_fd_sc_hd__xnor2_1
X_3679_ _1566_ _1567_ _1555_ VGND VGND VPWR VPWR _1568_ sky130_fd_sc_hd__o21ba_1
XFILLER_75_505 VPWR VGND VPWR VGND sky130_ef_sc_hd__decap_12
XFILLER_28_421 VPWR VGND VPWR VGND sky130_ef_sc_hd__decap_12
XFILLER_47_229 VGND VGND VPWR VPWR sky130_fd_sc_hd__fill_1
XFILLER_46_45 VGND VGND VPWR VPWR sky130_fd_sc_hd__fill_2
XFILLER_15_104 VGND VGND VPWR VPWR sky130_fd_sc_hd__fill_2
XFILLER_43_413 VGND VGND VPWR VPWR sky130_fd_sc_hd__decap_4
XFILLER_46_78 VGND VGND VPWR VPWR sky130_fd_sc_hd__decap_6
XFILLER_46_89 VGND VGND VPWR VPWR sky130_fd_sc_hd__fill_2
XFILLER_70_243 VGND VGND VPWR VPWR sky130_fd_sc_hd__decap_3
XFILLER_43_468 VPWR VGND VPWR VGND sky130_ef_sc_hd__decap_12
XFILLER_62_22 VGND VGND VPWR VPWR sky130_fd_sc_hd__fill_1
XTAP_TAPCELL_ROW_13_327 VGND VPWR sky130_fd_sc_hd__tapvpwrvgnd_1
XFILLER_23_181 VPWR VGND VPWR VGND sky130_ef_sc_hd__decap_12
XFILLER_7_39 VPWR VGND VPWR VGND sky130_ef_sc_hd__decap_12
XFILLER_11_92 VPWR VGND VPWR VGND sky130_ef_sc_hd__decap_12
XFILLER_3_553 VGND VGND VPWR VPWR sky130_fd_sc_hd__fill_1
XFILLER_78_321 VPWR VGND VPWR VGND sky130_ef_sc_hd__decap_12
XFILLER_78_365 VPWR VGND VPWR VGND sky130_ef_sc_hd__decap_12
XFILLER_93_335 VGND VGND VPWR VPWR sky130_fd_sc_hd__fill_1
XFILLER_34_435 VPWR VGND VPWR VGND sky130_ef_sc_hd__decap_12
XFILLER_61_221 VGND VGND VPWR VPWR sky130_fd_sc_hd__decap_3
X_2981_ _0926_ _0932_ _0933_ VGND VGND VPWR VPWR _0934_ sky130_fd_sc_hd__a21oi_1
Xinput31 D_b_01[6] VGND VGND VPWR VPWR net31 sky130_fd_sc_hd__clkbuf_1
Xinput20 D_b_00[3] VGND VGND VPWR VPWR net20 sky130_fd_sc_hd__buf_1
X_3602_ _1468_ _1476_ _1489_ VGND VGND VPWR VPWR _1491_ sky130_fd_sc_hd__and3_1
X_3533_ net193 net180 VGND VGND VPWR VPWR _1422_ sky130_fd_sc_hd__and2_1
X_3464_ systolic_unit_0.U_10.acc_0\[7\] systolic_unit_0.U_00.acc_0\[7\] net206 VGND
+ VGND VPWR VPWR _1377_ sky130_fd_sc_hd__mux2_1
X_2415_ _2112_ _2113_ VGND VGND VPWR VPWR _2114_ sky130_fd_sc_hd__nand2_1
X_3395_ _1296_ _1303_ _1314_ VGND VGND VPWR VPWR _1316_ sky130_fd_sc_hd__a21o_1
XFILLER_69_365 VGND VGND VPWR VPWR sky130_fd_sc_hd__decap_6
XFILLER_57_505 VGND VGND VPWR VPWR sky130_fd_sc_hd__fill_1
XFILLER_57_527 VGND VGND VPWR VPWR sky130_fd_sc_hd__decap_6
X_2346_ net267 net258 VGND VGND VPWR VPWR _2045_ sky130_fd_sc_hd__nand2_1
X_2277_ _1974_ _1975_ VGND VGND VPWR VPWR _1976_ sky130_fd_sc_hd__and2_1
X_4016_ row_count\[0\] net360 _1862_ VGND VGND VPWR VPWR _0271_ sky130_fd_sc_hd__a21oi_1
XFILLER_25_424 VGND VGND VPWR VPWR sky130_fd_sc_hd__decap_8
XFILLER_37_273 VGND VGND VPWR VPWR sky130_fd_sc_hd__fill_1
XTAP_TAPCELL_ROW_55_728 VGND VPWR sky130_fd_sc_hd__tapvpwrvgnd_1
XFILLER_80_530 VGND VGND VPWR VPWR sky130_fd_sc_hd__fill_2
XFILLER_16_37 VGND VGND VPWR VPWR sky130_fd_sc_hd__fill_2
Xclkbuf_leaf_32_clk clknet_2_0__leaf_clk VGND VGND VPWR VPWR clknet_leaf_32_clk sky130_fd_sc_hd__clkbuf_8
XFILLER_20_195 VGND VGND VPWR VPWR sky130_fd_sc_hd__fill_1
XFILLER_0_501 VGND VGND VPWR VPWR sky130_fd_sc_hd__decap_3
XFILLER_0_545 VGND VGND VPWR VPWR sky130_fd_sc_hd__decap_8
XFILLER_57_33 VPWR VGND VPWR VGND sky130_ef_sc_hd__decap_12
XFILLER_28_251 VGND VGND VPWR VPWR sky130_fd_sc_hd__fill_1
XFILLER_73_54 VGND VGND VPWR VPWR sky130_fd_sc_hd__fill_2
XFILLER_73_32 VPWR VGND VPWR VGND sky130_ef_sc_hd__decap_12
XFILLER_71_541 VPWR VGND VPWR VGND sky130_ef_sc_hd__decap_12
XFILLER_16_457 VPWR VGND VPWR VGND sky130_ef_sc_hd__decap_12
XTAP_TAPCELL_ROW_26_452 VGND VPWR sky130_fd_sc_hd__tapvpwrvgnd_1
XFILLER_7_166 VGND VGND VPWR VPWR sky130_fd_sc_hd__fill_2
XFILLER_7_133 VGND VGND VPWR VPWR sky130_fd_sc_hd__fill_1
XFILLER_7_199 VGND VGND VPWR VPWR sky130_fd_sc_hd__decap_6
XFILLER_22_91 VGND VGND VPWR VPWR sky130_fd_sc_hd__decap_4
XPHY_EDGE_ROW_13_Left_107 VGND VGND VPWR VPWR sky130_fd_sc_hd__decap_3
X_2200_ systolic_unit_0.U_11.acc_0\[0\] systolic_unit_0.U_11.acc_1\[0\] net147 VGND
+ VGND VPWR VPWR _1900_ sky130_fd_sc_hd__mux2_1
X_3180_ _1095_ _1096_ _1100_ VGND VGND VPWR VPWR _1101_ sky130_fd_sc_hd__a21bo_1
XFILLER_39_505 VPWR VGND VPWR VGND sky130_ef_sc_hd__decap_12
X_2131_ net71 VGND VGND VPWR VPWR net72 sky130_fd_sc_hd__inv_2
XFILLER_93_165 VGND VGND VPWR VPWR sky130_fd_sc_hd__decap_3
XFILLER_81_349 VGND VGND VPWR VPWR sky130_fd_sc_hd__decap_3
XPHY_EDGE_ROW_22_Left_116 VGND VGND VPWR VPWR sky130_fd_sc_hd__decap_3
X_2964_ _0910_ _0916_ VGND VGND VPWR VPWR _0917_ sky130_fd_sc_hd__nand2_1
Xclkbuf_leaf_14_clk clknet_2_2__leaf_clk VGND VGND VPWR VPWR clknet_leaf_14_clk sky130_fd_sc_hd__clkbuf_8
XTAP_TAPCELL_ROW_60_775 VGND VPWR sky130_fd_sc_hd__tapvpwrvgnd_1
X_2895_ net130 net171 _0846_ VGND VGND VPWR VPWR _0848_ sky130_fd_sc_hd__and3_1
XFILLER_89_405 VGND VGND VPWR VPWR sky130_fd_sc_hd__decap_4
X_3516_ net318 net76 net83 systolic_unit_0.U_00.acc_1\[8\] _1413_ VGND VGND VPWR VPWR
+ _0297_ sky130_fd_sc_hd__a221o_1
XPHY_EDGE_ROW_4_Right_4 VGND VGND VPWR VPWR sky130_fd_sc_hd__decap_3
XPHY_EDGE_ROW_31_Left_125 VGND VGND VPWR VPWR sky130_fd_sc_hd__decap_3
X_4496_ clknet_leaf_0_clk net311 _0220_ VGND VGND VPWR VPWR systolic_unit_0.out_acc_0_r1\[11\]
+ sky130_fd_sc_hd__dfrtp_1
X_3447_ _1336_ _1337_ _1161_ VGND VGND VPWR VPWR _1364_ sky130_fd_sc_hd__o21a_1
X_3378_ _1297_ _1286_ _1274_ VGND VGND VPWR VPWR _1299_ sky130_fd_sc_hd__or3_4
XFILLER_84_121 VPWR VGND VPWR VGND sky130_ef_sc_hd__decap_12
X_2329_ _2015_ _2027_ _2000_ VGND VGND VPWR VPWR _2028_ sky130_fd_sc_hd__a21oi_1
XFILLER_57_346 VPWR VGND VPWR VGND sky130_ef_sc_hd__decap_12
XFILLER_84_165 VPWR VGND VPWR VGND sky130_ef_sc_hd__decap_12
XPHY_EDGE_ROW_40_Left_134 VGND VGND VPWR VPWR sky130_fd_sc_hd__decap_3
XFILLER_80_360 VGND VGND VPWR VPWR sky130_fd_sc_hd__fill_1
XFILLER_13_405 VPWR VGND VPWR VGND sky130_ef_sc_hd__decap_12
XFILLER_25_265 VPWR VGND VPWR VGND sky130_ef_sc_hd__decap_12
XFILLER_13_449 VPWR VGND VPWR VGND sky130_ef_sc_hd__decap_12
XTAP_TAPCELL_ROW_23_422 VGND VPWR sky130_fd_sc_hd__tapvpwrvgnd_1
XFILLER_43_57 VPWR VGND VPWR VGND sky130_ef_sc_hd__decap_12
XFILLER_4_29 VPWR VGND VPWR VGND sky130_ef_sc_hd__decap_12
XFILLER_4_169 VGND VGND VPWR VPWR sky130_fd_sc_hd__decap_8
XFILLER_48_335 VPWR VGND VPWR VGND sky130_ef_sc_hd__decap_12
XTAP_TAPCELL_ROW_89_1044 VGND VPWR sky130_fd_sc_hd__tapvpwrvgnd_1
XFILLER_84_53 VPWR VGND VPWR VGND sky130_ef_sc_hd__decap_12
XFILLER_84_97 VPWR VGND VPWR VGND sky130_ef_sc_hd__decap_12
XFILLER_16_221 VGND VGND VPWR VPWR sky130_fd_sc_hd__fill_2
XFILLER_44_530 VGND VGND VPWR VPWR sky130_fd_sc_hd__fill_2
XFILLER_71_393 VPWR VGND VPWR VGND sky130_ef_sc_hd__decap_12
XFILLER_31_268 VGND VGND VPWR VPWR sky130_fd_sc_hd__decap_4
X_2680_ _0624_ _0630_ VGND VGND VPWR VPWR _0633_ sky130_fd_sc_hd__xor2_1
XFILLER_8_475 VGND VGND VPWR VPWR sky130_fd_sc_hd__fill_1
X_4350_ clknet_leaf_11_clk _0323_ _0074_ VGND VGND VPWR VPWR systolic_unit_0.U_01.acc_1\[2\]
+ sky130_fd_sc_hd__dfrtp_1
X_3301_ _1174_ _1219_ _1221_ VGND VGND VPWR VPWR _1222_ sky130_fd_sc_hd__nand3_1
X_4281_ clknet_leaf_27_clk _0262_ VGND VGND VPWR VPWR switch_r1 sky130_fd_sc_hd__dfxtp_1
XFILLER_86_419 VGND VGND VPWR VPWR sky130_fd_sc_hd__fill_1
X_3232_ _1113_ _1127_ _1139_ VGND VGND VPWR VPWR _1153_ sky130_fd_sc_hd__a21o_1
XFILLER_3_191 VGND VGND VPWR VPWR sky130_fd_sc_hd__decap_3
Xclkbuf_leaf_3_clk clknet_2_0__leaf_clk VGND VGND VPWR VPWR clknet_leaf_3_clk sky130_fd_sc_hd__clkbuf_8
X_3163_ _1081_ _1082_ VGND VGND VPWR VPWR _1084_ sky130_fd_sc_hd__or2_1
XFILLER_39_335 VGND VGND VPWR VPWR sky130_fd_sc_hd__fill_1
XFILLER_81_113 VPWR VGND VPWR VGND sky130_ef_sc_hd__decap_12
X_3094_ net108 systolic_unit_0.U_00.out_b\[6\] net153 net109 VGND VGND VPWR VPWR _1015_
+ sky130_fd_sc_hd__a22oi_1
XTAP_TAPCELL_ROW_65_823 VGND VPWR sky130_fd_sc_hd__tapvpwrvgnd_1
XFILLER_66_187 VGND VGND VPWR VPWR sky130_fd_sc_hd__decap_8
XFILLER_47_390 VGND VGND VPWR VPWR sky130_fd_sc_hd__fill_2
XFILLER_35_552 VGND VGND VPWR VPWR sky130_fd_sc_hd__fill_2
X_3996_ row_count\[1\] row_count\[2\] row_count\[0\] VGND VGND VPWR VPWR _1848_ sky130_fd_sc_hd__or3b_1
XFILLER_22_235 VPWR VGND VPWR VGND sky130_ef_sc_hd__decap_12
XFILLER_22_257 VPWR VGND VPWR VGND sky130_ef_sc_hd__decap_12
X_2947_ _0893_ _0899_ VGND VGND VPWR VPWR _0900_ sky130_fd_sc_hd__xor2_1
X_2878_ _0824_ _0830_ VGND VGND VPWR VPWR _0831_ sky130_fd_sc_hd__nand2_1
X_4479_ clknet_leaf_32_clk net295 _0203_ VGND VGND VPWR VPWR systolic_unit_0.out_acc_1_r1\[10\]
+ sky130_fd_sc_hd__dfrtp_1
XFILLER_77_408 VGND VGND VPWR VPWR sky130_fd_sc_hd__fill_2
XFILLER_57_110 VGND VGND VPWR VPWR sky130_fd_sc_hd__fill_2
XFILLER_85_430 VGND VGND VPWR VPWR sky130_fd_sc_hd__decap_3
XPHY_EDGE_ROW_79_Right_79 VGND VGND VPWR VPWR sky130_fd_sc_hd__decap_3
XFILLER_57_165 VGND VGND VPWR VPWR sky130_fd_sc_hd__decap_3
XFILLER_72_146 VGND VGND VPWR VPWR sky130_fd_sc_hd__decap_8
XFILLER_45_349 VGND VGND VPWR VPWR sky130_fd_sc_hd__decap_8
XTAP_TAPCELL_ROW_0_194 VGND VPWR sky130_fd_sc_hd__tapvpwrvgnd_1
XPHY_EDGE_ROW_88_Right_88 VGND VGND VPWR VPWR sky130_fd_sc_hd__decap_3
XFILLER_79_86 VGND VGND VPWR VPWR sky130_fd_sc_hd__fill_2
XTAP_TAPCELL_ROW_79_948 VGND VPWR sky130_fd_sc_hd__tapvpwrvgnd_1
XFILLER_36_305 VGND VGND VPWR VPWR sky130_fd_sc_hd__decap_3
XFILLER_76_496 VPWR VGND VPWR VGND sky130_ef_sc_hd__decap_12
XFILLER_36_349 VGND VGND VPWR VPWR sky130_fd_sc_hd__decap_6
XFILLER_63_113 VGND VGND VPWR VPWR sky130_fd_sc_hd__decap_8
XFILLER_17_541 VPWR VGND VPWR VGND sky130_ef_sc_hd__decap_12
XFILLER_32_522 VGND VGND VPWR VPWR sky130_fd_sc_hd__decap_8
XFILLER_32_533 VPWR VGND VPWR VGND sky130_ef_sc_hd__decap_12
XTAP_TAPCELL_ROW_34_528 VGND VPWR sky130_fd_sc_hd__tapvpwrvgnd_1
X_3850_ _1734_ _1738_ VGND VGND VPWR VPWR _1739_ sky130_fd_sc_hd__nand2_1
X_2801_ _0750_ _0753_ VGND VGND VPWR VPWR _0754_ sky130_fd_sc_hd__xnor2_1
XTAP_TAPCELL_ROW_70_870 VGND VPWR sky130_fd_sc_hd__tapvpwrvgnd_1
X_3781_ _1655_ _1669_ VGND VGND VPWR VPWR _1670_ sky130_fd_sc_hd__xor2_2
X_2732_ _0649_ _0650_ VGND VGND VPWR VPWR _0685_ sky130_fd_sc_hd__xnor2_1
X_2663_ systolic_unit_0.U_01.acc_1\[12\] systolic_unit_0.U_01.acc_0\[12\] net139 VGND
+ VGND VPWR VPWR _0616_ sky130_fd_sc_hd__mux2_1
X_4402_ clknet_leaf_13_clk net119 _0126_ VGND VGND VPWR VPWR systolic_unit_0.U_01.out_b\[6\]
+ sky130_fd_sc_hd__dfrtp_4
X_2594_ _0535_ _0569_ VGND VGND VPWR VPWR _0574_ sky130_fd_sc_hd__or2_1
X_4333_ clknet_leaf_32_clk _0314_ _0057_ VGND VGND VPWR VPWR systolic_unit_0.U_10.acc_0\[9\]
+ sky130_fd_sc_hd__dfrtp_1
Xfanout218 net5 VGND VGND VPWR VPWR net218 sky130_fd_sc_hd__buf_2
Xfanout207 drain_even VGND VGND VPWR VPWR net207 sky130_fd_sc_hd__clkbuf_4
Xfanout229 net231 VGND VGND VPWR VPWR net229 sky130_fd_sc_hd__clkbuf_4
X_4264_ clknet_leaf_17_clk net420 _0000_ VGND VGND VPWR VPWR systolic_unit_0.U_11.acc_1\[0\]
+ sky130_fd_sc_hd__dfrtp_1
X_3215_ _1134_ _1135_ VGND VGND VPWR VPWR _1136_ sky130_fd_sc_hd__nor2_1
X_4195_ net237 VGND VGND VPWR VPWR _0176_ sky130_fd_sc_hd__inv_2
XFILLER_39_143 VGND VGND VPWR VPWR sky130_fd_sc_hd__fill_2
X_3146_ net109 net155 VGND VGND VPWR VPWR _1067_ sky130_fd_sc_hd__and2_1
XFILLER_27_305 VPWR VGND VPWR VGND sky130_ef_sc_hd__decap_12
X_3077_ _0996_ _0997_ systolic_unit_0.U_00.out_b\[5\] net103 VGND VGND VPWR VPWR _0998_
+ sky130_fd_sc_hd__and4bb_1
XFILLER_27_349 VGND VGND VPWR VPWR sky130_fd_sc_hd__decap_4
XFILLER_54_124 VPWR VGND VPWR VGND sky130_ef_sc_hd__decap_12
XFILLER_82_477 VPWR VGND VPWR VGND sky130_ef_sc_hd__decap_12
XFILLER_24_15 VPWR VGND VPWR VGND sky130_ef_sc_hd__decap_12
XFILLER_35_393 VGND VGND VPWR VPWR sky130_fd_sc_hd__decap_6
XFILLER_50_396 VGND VGND VPWR VPWR sky130_fd_sc_hd__decap_3
X_3979_ net97 _1813_ _1841_ VGND VGND VPWR VPWR _0250_ sky130_fd_sc_hd__a21o_1
XFILLER_6_209 VPWR VGND VPWR VGND sky130_ef_sc_hd__decap_12
XTAP_TAPCELL_ROW_5_253 VGND VPWR sky130_fd_sc_hd__tapvpwrvgnd_1
XFILLER_58_474 VGND VGND VPWR VPWR sky130_fd_sc_hd__fill_2
XFILLER_85_293 VGND VGND VPWR VPWR sky130_fd_sc_hd__decap_4
XTAP_TAPCELL_ROW_86_1014 VGND VPWR sky130_fd_sc_hd__tapvpwrvgnd_1
XFILLER_45_113 VGND VGND VPWR VPWR sky130_fd_sc_hd__decap_6
XFILLER_65_44 VPWR VGND VPWR VGND sky130_ef_sc_hd__decap_12
XFILLER_73_477 VPWR VGND VPWR VGND sky130_ef_sc_hd__decap_12
XTAP_TAPCELL_ROW_84_995 VGND VPWR sky130_fd_sc_hd__tapvpwrvgnd_1
XFILLER_14_533 VPWR VGND VPWR VGND sky130_ef_sc_hd__decap_12
XFILLER_14_81 VGND VGND VPWR VPWR sky130_fd_sc_hd__decap_3
XFILLER_5_297 VGND VGND VPWR VPWR sky130_fd_sc_hd__decap_4
Xinput7 D_a_00[6] VGND VGND VPWR VPWR net7 sky130_fd_sc_hd__buf_1
X_3000_ _0663_ _0942_ _0632_ VGND VGND VPWR VPWR _0952_ sky130_fd_sc_hd__a21oi_1
X_3902_ systolic_unit_0.U_01.acc_0\[14\] net75 net82 systolic_unit_0.U_11.acc_0\[14\]
+ VGND VGND VPWR VPWR _1790_ sky130_fd_sc_hd__a22o_1
XFILLER_32_363 VGND VGND VPWR VPWR sky130_fd_sc_hd__fill_1
X_3833_ _1710_ _1721_ VGND VGND VPWR VPWR _1722_ sky130_fd_sc_hd__nor2_1
X_3764_ _1652_ _1650_ VGND VGND VPWR VPWR _1653_ sky130_fd_sc_hd__and2b_1
X_3695_ _1577_ _1583_ VGND VGND VPWR VPWR _1584_ sky130_fd_sc_hd__nand2_1
X_2715_ systolic_unit_0.U_01.acc_1\[8\] systolic_unit_0.U_01.acc_0\[8\] net140 VGND
+ VGND VPWR VPWR _0668_ sky130_fd_sc_hd__mux2_1
X_2646_ net167 net117 _0598_ VGND VGND VPWR VPWR _0599_ sky130_fd_sc_hd__and3_1
XFILLER_87_503 VGND VGND VPWR VPWR sky130_fd_sc_hd__fill_1
X_2577_ _0558_ _0561_ VGND VGND VPWR VPWR _0562_ sky130_fd_sc_hd__xnor2_1
X_4316_ clknet_leaf_31_clk _0297_ _0040_ VGND VGND VPWR VPWR systolic_unit_0.U_10.acc_1\[8\]
+ sky130_fd_sc_hd__dfrtp_1
XFILLER_19_15 VPWR VGND VPWR VGND sky130_ef_sc_hd__decap_12
X_4247_ net243 VGND VGND VPWR VPWR _0228_ sky130_fd_sc_hd__inv_2
X_4178_ net251 VGND VGND VPWR VPWR _0159_ sky130_fd_sc_hd__inv_2
XFILLER_67_260 VPWR VGND VPWR VGND sky130_ef_sc_hd__decap_12
XTAP_TAPCELL_ROW_2_223 VGND VPWR sky130_fd_sc_hd__tapvpwrvgnd_1
XFILLER_27_113 VPWR VGND VPWR VGND sky130_ef_sc_hd__decap_12
X_3129_ _1042_ _1049_ VGND VGND VPWR VPWR _1050_ sky130_fd_sc_hd__or2_1
XFILLER_55_466 VPWR VGND VPWR VGND sky130_ef_sc_hd__decap_12
XFILLER_11_503 VGND VGND VPWR VPWR sky130_fd_sc_hd__fill_1
XFILLER_7_529 VPWR VGND VPWR VGND sky130_ef_sc_hd__decap_12
XFILLER_51_68 VGND VGND VPWR VPWR sky130_fd_sc_hd__fill_2
XFILLER_2_256 VGND VGND VPWR VPWR sky130_fd_sc_hd__decap_8
XFILLER_4_3 VPWR VGND VPWR VGND sky130_ef_sc_hd__decap_12
XTAP_TAPCELL_ROW_92_1073 VGND VPWR sky130_fd_sc_hd__tapvpwrvgnd_1
XFILLER_76_21 VGND VGND VPWR VPWR sky130_fd_sc_hd__decap_6
XFILLER_93_517 VPWR VGND VPWR VGND sky130_ef_sc_hd__decap_12
XFILLER_65_208 VPWR VGND VPWR VGND sky130_ef_sc_hd__decap_12
XFILLER_46_433 VPWR VGND VPWR VGND sky130_ef_sc_hd__decap_12
XFILLER_73_252 VPWR VGND VPWR VGND sky130_ef_sc_hd__decap_12
XFILLER_18_135 VGND VGND VPWR VPWR sky130_fd_sc_hd__decap_4
XFILLER_46_477 VGND VGND VPWR VPWR sky130_fd_sc_hd__decap_8
XFILLER_92_53 VPWR VGND VPWR VGND sky130_ef_sc_hd__decap_12
XTAP_TAPCELL_ROW_44_623 VGND VPWR sky130_fd_sc_hd__tapvpwrvgnd_1
XFILLER_92_97 VPWR VGND VPWR VGND sky130_ef_sc_hd__decap_12
XFILLER_33_138 VGND VGND VPWR VPWR sky130_fd_sc_hd__decap_4
XTAP_TAPCELL_ROW_16_358 VGND VPWR sky130_fd_sc_hd__tapvpwrvgnd_1
XFILLER_14_352 VPWR VGND VPWR VGND sky130_ef_sc_hd__decap_12
X_3480_ _1317_ _1323_ VGND VGND VPWR VPWR _1389_ sky130_fd_sc_hd__xnor2_1
X_2500_ _0478_ _0483_ _0484_ VGND VGND VPWR VPWR _0485_ sky130_fd_sc_hd__or3_1
X_2431_ _2090_ _2116_ _2128_ VGND VGND VPWR VPWR _2130_ sky130_fd_sc_hd__a21o_1
X_2362_ _2020_ _2060_ VGND VGND VPWR VPWR _2061_ sky130_fd_sc_hd__or2_1
X_2293_ _1951_ _1956_ VGND VGND VPWR VPWR _1992_ sky130_fd_sc_hd__xor2_1
X_4101_ net248 VGND VGND VPWR VPWR _0082_ sky130_fd_sc_hd__inv_2
X_4032_ net250 VGND VGND VPWR VPWR _0013_ sky130_fd_sc_hd__inv_2
X_3816_ _1676_ _1677_ VGND VGND VPWR VPWR _1705_ sky130_fd_sc_hd__xnor2_1
X_3747_ _1632_ _1634_ VGND VGND VPWR VPWR _1636_ sky130_fd_sc_hd__xor2_1
X_3678_ _1536_ _1554_ VGND VGND VPWR VPWR _1567_ sky130_fd_sc_hd__xnor2_1
X_2629_ net99 _0578_ net79 systolic_unit_0.U_00.acc_1\[8\] VGND VGND VPWR VPWR _0361_
+ sky130_fd_sc_hd__a22o_1
XFILLER_87_333 VGND VGND VPWR VPWR sky130_fd_sc_hd__decap_3
XFILLER_75_517 VPWR VGND VPWR VGND sky130_ef_sc_hd__decap_12
XFILLER_28_433 VGND VGND VPWR VPWR sky130_fd_sc_hd__decap_8
XTAP_TAPCELL_ROW_58_748 VGND VPWR sky130_fd_sc_hd__tapvpwrvgnd_1
XFILLER_28_477 VGND VGND VPWR VPWR sky130_fd_sc_hd__decap_6
XFILLER_30_119 VPWR VGND VPWR VGND sky130_ef_sc_hd__decap_12
XTAP_TAPCELL_ROW_13_328 VGND VPWR sky130_fd_sc_hd__tapvpwrvgnd_1
XFILLER_23_193 VGND VGND VPWR VPWR sky130_fd_sc_hd__decap_8
XFILLER_7_337 VGND VGND VPWR VPWR sky130_fd_sc_hd__decap_8
XFILLER_78_333 VGND VGND VPWR VPWR sky130_fd_sc_hd__decap_6
XFILLER_78_377 VGND VGND VPWR VPWR sky130_fd_sc_hd__decap_8
XFILLER_78_399 VPWR VGND VPWR VGND sky130_ef_sc_hd__decap_12
XFILLER_46_230 VGND VGND VPWR VPWR sky130_fd_sc_hd__decap_3
XFILLER_34_447 VPWR VGND VPWR VGND sky130_ef_sc_hd__decap_12
XFILLER_61_244 VPWR VGND VPWR VGND sky130_ef_sc_hd__decap_12
X_2980_ _0812_ _0929_ _0811_ VGND VGND VPWR VPWR _0933_ sky130_fd_sc_hd__a21o_1
Xinput21 D_b_00[4] VGND VGND VPWR VPWR net21 sky130_fd_sc_hd__clkbuf_1
Xinput10 D_a_10[1] VGND VGND VPWR VPWR net10 sky130_fd_sc_hd__clkbuf_1
X_3601_ _1476_ _1489_ _1468_ VGND VGND VPWR VPWR _1490_ sky130_fd_sc_hd__a21oi_1
Xinput32 D_b_01[7] VGND VGND VPWR VPWR net32 sky130_fd_sc_hd__clkbuf_1
X_3532_ net308 _1404_ _1406_ net359 _1421_ VGND VGND VPWR VPWR _0289_ sky130_fd_sc_hd__o221a_1
X_3463_ net309 _1356_ _1375_ _1376_ VGND VGND VPWR VPWR _0313_ sky130_fd_sc_hd__a22o_1
XFILLER_69_311 VPWR VGND VPWR VGND sky130_ef_sc_hd__decap_12
X_2414_ _2110_ _2111_ VGND VGND VPWR VPWR _2113_ sky130_fd_sc_hd__or2_1
X_3394_ _1296_ _1303_ _1314_ VGND VGND VPWR VPWR _1315_ sky130_fd_sc_hd__and3_1
X_2345_ _2006_ _2038_ _2043_ VGND VGND VPWR VPWR _2044_ sky130_fd_sc_hd__nand3_1
X_2276_ _1963_ _1971_ _1973_ VGND VGND VPWR VPWR _1975_ sky130_fd_sc_hd__or3_1
X_4015_ row_count\[0\] row_count\[1\] _1848_ _1850_ VGND VGND VPWR VPWR _1862_ sky130_fd_sc_hd__o211ai_1
XFILLER_37_241 VGND VGND VPWR VPWR sky130_fd_sc_hd__decap_3
XFILLER_80_553 VGND VGND VPWR VPWR sky130_fd_sc_hd__fill_1
XFILLER_16_27 VGND VGND VPWR VPWR sky130_fd_sc_hd__fill_1
XFILLER_25_447 VGND VGND VPWR VPWR sky130_fd_sc_hd__fill_1
XFILLER_52_277 VPWR VGND VPWR VGND sky130_ef_sc_hd__decap_12
XFILLER_52_299 VGND VGND VPWR VPWR sky130_fd_sc_hd__decap_8
XFILLER_20_141 VPWR VGND VPWR VGND sky130_ef_sc_hd__decap_12
XFILLER_32_26 VGND VGND VPWR VPWR sky130_fd_sc_hd__fill_2
XFILLER_32_48 VPWR VGND VPWR VGND sky130_ef_sc_hd__decap_12
XFILLER_4_307 VGND VGND VPWR VPWR sky130_fd_sc_hd__fill_1
XFILLER_79_119 VGND VGND VPWR VPWR sky130_fd_sc_hd__decap_6
XFILLER_75_303 VGND VGND VPWR VPWR sky130_fd_sc_hd__decap_6
XFILLER_57_45 VGND VGND VPWR VPWR sky130_fd_sc_hd__decap_8
XFILLER_57_89 VGND VGND VPWR VPWR sky130_fd_sc_hd__decap_3
XFILLER_90_306 VGND VGND VPWR VPWR sky130_fd_sc_hd__fill_2
XFILLER_71_553 VGND VGND VPWR VPWR sky130_fd_sc_hd__fill_1
XFILLER_16_469 VGND VGND VPWR VPWR sky130_fd_sc_hd__decap_6
XTAP_TAPCELL_ROW_26_453 VGND VPWR sky130_fd_sc_hd__tapvpwrvgnd_1
XFILLER_31_406 VGND VGND VPWR VPWR sky130_fd_sc_hd__decap_8
XFILLER_24_480 VPWR VGND VPWR VGND sky130_ef_sc_hd__decap_12
XFILLER_31_428 VPWR VGND VPWR VGND sky130_ef_sc_hd__decap_12
XFILLER_22_70 VGND VGND VPWR VPWR sky130_fd_sc_hd__decap_6
XFILLER_3_340 VGND VGND VPWR VPWR sky130_fd_sc_hd__decap_4
XFILLER_39_517 VGND VGND VPWR VPWR sky130_fd_sc_hd__decap_6
XFILLER_81_328 VGND VGND VPWR VPWR sky130_fd_sc_hd__decap_8
XFILLER_22_406 VGND VGND VPWR VPWR sky130_fd_sc_hd__fill_1
X_2963_ _0915_ VGND VGND VPWR VPWR _0916_ sky130_fd_sc_hd__inv_2
X_2894_ net130 net171 VGND VGND VPWR VPWR _0847_ sky130_fd_sc_hd__nand2_1
XTAP_TAPCELL_ROW_60_776 VGND VPWR sky130_fd_sc_hd__tapvpwrvgnd_1
XFILLER_8_83 VGND VGND VPWR VPWR sky130_fd_sc_hd__fill_1
X_3515_ net133 _1374_ VGND VGND VPWR VPWR _1413_ sky130_fd_sc_hd__nor2_1
X_4495_ clknet_leaf_32_clk net304 _0219_ VGND VGND VPWR VPWR systolic_unit_0.out_acc_0_r1\[10\]
+ sky130_fd_sc_hd__dfrtp_1
XFILLER_89_439 VGND VGND VPWR VPWR sky130_fd_sc_hd__decap_3
X_3446_ systolic_unit_0.U_10.acc_0\[11\] systolic_unit_0.U_00.acc_0\[11\] net206 VGND
+ VGND VPWR VPWR _1363_ sky130_fd_sc_hd__mux2_1
X_3377_ _1274_ _1286_ _1297_ VGND VGND VPWR VPWR _1298_ sky130_fd_sc_hd__nor3_1
X_2328_ _2015_ _2025_ _2026_ VGND VGND VPWR VPWR _2027_ sky130_fd_sc_hd__nand3_1
XFILLER_84_133 VGND VGND VPWR VPWR sky130_fd_sc_hd__decap_6
XTAP_TAPCELL_ROW_68_843 VGND VPWR sky130_fd_sc_hd__tapvpwrvgnd_1
XFILLER_57_358 VGND VGND VPWR VPWR sky130_fd_sc_hd__decap_8
XFILLER_84_177 VPWR VGND VPWR VGND sky130_ef_sc_hd__decap_12
X_2259_ _1934_ _1935_ _1936_ VGND VGND VPWR VPWR _1958_ sky130_fd_sc_hd__a21oi_1
XFILLER_53_520 VGND VGND VPWR VPWR sky130_fd_sc_hd__decap_3
XFILLER_65_391 VGND VGND VPWR VPWR sky130_fd_sc_hd__fill_1
XFILLER_13_417 VPWR VGND VPWR VGND sky130_ef_sc_hd__decap_12
XFILLER_25_277 VGND VGND VPWR VPWR sky130_fd_sc_hd__decap_3
XFILLER_43_36 VGND VGND VPWR VPWR sky130_fd_sc_hd__decap_3
XTAP_TAPCELL_ROW_23_423 VGND VPWR sky130_fd_sc_hd__tapvpwrvgnd_1
XFILLER_43_69 VPWR VGND VPWR VGND sky130_ef_sc_hd__decap_12
XFILLER_0_321 VGND VGND VPWR VPWR sky130_fd_sc_hd__decap_4
XFILLER_0_343 VGND VGND VPWR VPWR sky130_fd_sc_hd__decap_8
XFILLER_0_365 VGND VGND VPWR VPWR sky130_fd_sc_hd__fill_2
XFILLER_0_398 VPWR VGND VPWR VGND sky130_ef_sc_hd__decap_12
XTAP_TAPCELL_ROW_89_1045 VGND VPWR sky130_fd_sc_hd__tapvpwrvgnd_1
XFILLER_48_358 VGND VGND VPWR VPWR sky130_fd_sc_hd__fill_1
XFILLER_84_65 VPWR VGND VPWR VGND sky130_ef_sc_hd__decap_12
XFILLER_71_361 VGND VGND VPWR VPWR sky130_fd_sc_hd__fill_1
XFILLER_17_92 VPWR VGND VPWR VGND sky130_ef_sc_hd__decap_12
XFILLER_71_383 VGND VGND VPWR VPWR sky130_fd_sc_hd__decap_3
XFILLER_31_225 VPWR VGND VPWR VGND sky130_ef_sc_hd__decap_12
XFILLER_8_421 VPWR VGND VPWR VGND sky130_ef_sc_hd__decap_12
XFILLER_69_6 VPWR VGND VPWR VGND sky130_ef_sc_hd__decap_12
X_3300_ _1128_ _1211_ _1220_ VGND VGND VPWR VPWR _1221_ sky130_fd_sc_hd__nor3_1
X_4280_ clknet_leaf_28_clk _0261_ VGND VGND VPWR VPWR switch sky130_fd_sc_hd__dfxtp_1
XFILLER_86_409 VGND VGND VPWR VPWR sky130_fd_sc_hd__fill_1
XFILLER_79_461 VGND VGND VPWR VPWR sky130_fd_sc_hd__decap_6
X_3231_ _1145_ _1150_ VGND VGND VPWR VPWR _1152_ sky130_fd_sc_hd__xnor2_1
X_3162_ _1081_ _1082_ VGND VGND VPWR VPWR _1083_ sky130_fd_sc_hd__nand2_1
X_3093_ net109 net108 systolic_unit_0.U_00.out_b\[6\] net153 VGND VGND VPWR VPWR _1014_
+ sky130_fd_sc_hd__and4_1
XFILLER_81_125 VGND VGND VPWR VPWR sky130_fd_sc_hd__fill_2
XFILLER_35_520 VPWR VGND VPWR VGND sky130_ef_sc_hd__decap_12
XFILLER_81_169 VPWR VGND VPWR VGND sky130_ef_sc_hd__decap_12
XFILLER_50_501 VGND VGND VPWR VPWR sky130_fd_sc_hd__decap_8
XFILLER_62_394 VGND VGND VPWR VPWR sky130_fd_sc_hd__decap_3
XFILLER_22_247 VGND VGND VPWR VPWR sky130_fd_sc_hd__decap_4
X_3995_ net324 _1847_ VGND VGND VPWR VPWR _0265_ sky130_fd_sc_hd__and2_1
XFILLER_22_269 VGND VGND VPWR VPWR sky130_fd_sc_hd__decap_3
X_2946_ _0896_ _0897_ _0895_ VGND VGND VPWR VPWR _0899_ sky130_fd_sc_hd__o21bai_1
X_2877_ net128 net171 _0829_ _0827_ VGND VGND VPWR VPWR _0830_ sky130_fd_sc_hd__a31o_1
XFILLER_89_225 VPWR VGND VPWR VGND sky130_ef_sc_hd__decap_12
X_4478_ clknet_leaf_32_clk net310 _0202_ VGND VGND VPWR VPWR systolic_unit_0.out_acc_1_r1\[9\]
+ sky130_fd_sc_hd__dfrtp_1
X_3429_ _1347_ _1349_ VGND VGND VPWR VPWR _1350_ sky130_fd_sc_hd__xnor2_1
XFILLER_26_531 VGND VGND VPWR VPWR sky130_fd_sc_hd__fill_1
XFILLER_26_553 VGND VGND VPWR VPWR sky130_fd_sc_hd__fill_1
XFILLER_54_57 VGND VGND VPWR VPWR sky130_fd_sc_hd__fill_1
XFILLER_13_225 VGND VGND VPWR VPWR sky130_fd_sc_hd__fill_2
XTAP_TAPCELL_ROW_0_195 VGND VPWR sky130_fd_sc_hd__tapvpwrvgnd_1
XFILLER_80_191 VGND VGND VPWR VPWR sky130_fd_sc_hd__decap_4
XFILLER_13_247 VGND VGND VPWR VPWR sky130_fd_sc_hd__decap_8
XTAP_TAPCELL_ROW_79_949 VGND VPWR sky130_fd_sc_hd__tapvpwrvgnd_1
XTAP_TAPCELL_ROW_8_273 VGND VPWR sky130_fd_sc_hd__tapvpwrvgnd_1
XFILLER_48_122 VPWR VGND VPWR VGND sky130_ef_sc_hd__decap_12
XFILLER_36_317 VGND VGND VPWR VPWR sky130_fd_sc_hd__decap_3
XFILLER_91_445 VGND VGND VPWR VPWR sky130_fd_sc_hd__decap_3
XFILLER_29_391 VGND VGND VPWR VPWR sky130_fd_sc_hd__fill_1
XFILLER_17_553 VGND VGND VPWR VPWR sky130_fd_sc_hd__fill_1
XFILLER_44_350 VPWR VGND VPWR VGND sky130_ef_sc_hd__decap_12
XFILLER_63_169 VPWR VGND VPWR VGND sky130_ef_sc_hd__decap_12
XTAP_TAPCELL_ROW_34_529 VGND VPWR sky130_fd_sc_hd__tapvpwrvgnd_1
XFILLER_32_545 VGND VGND VPWR VPWR sky130_fd_sc_hd__decap_8
X_2800_ _0751_ _0752_ VGND VGND VPWR VPWR _0753_ sky130_fd_sc_hd__nor2_1
XTAP_TAPCELL_ROW_70_871 VGND VPWR sky130_fd_sc_hd__tapvpwrvgnd_1
X_3780_ _1656_ _1667_ VGND VGND VPWR VPWR _1669_ sky130_fd_sc_hd__xnor2_2
X_2731_ _0681_ _0683_ VGND VGND VPWR VPWR _0684_ sky130_fd_sc_hd__nor2_1
X_2662_ net123 net165 _0614_ VGND VGND VPWR VPWR _0615_ sky130_fd_sc_hd__and3_1
X_4401_ clknet_leaf_13_clk net121 _0125_ VGND VGND VPWR VPWR systolic_unit_0.U_01.out_b\[5\]
+ sky130_fd_sc_hd__dfrtp_2
X_2593_ net375 net88 _0573_ net208 VGND VGND VPWR VPWR _0380_ sky130_fd_sc_hd__a22o_1
XFILLER_5_51 VGND VGND VPWR VPWR sky130_fd_sc_hd__decap_4
X_4332_ clknet_leaf_31_clk _0313_ _0056_ VGND VGND VPWR VPWR systolic_unit_0.U_10.acc_0\[8\]
+ sky130_fd_sc_hd__dfrtp_1
X_4263_ net222 VGND VGND VPWR VPWR _0244_ sky130_fd_sc_hd__inv_2
Xfanout208 net209 VGND VGND VPWR VPWR net208 sky130_fd_sc_hd__buf_2
Xfanout219 net5 VGND VGND VPWR VPWR net219 sky130_fd_sc_hd__clkbuf_2
X_3214_ net160 net105 _1132_ _1133_ VGND VGND VPWR VPWR _1135_ sky130_fd_sc_hd__o2bb2a_1
X_4194_ net233 VGND VGND VPWR VPWR _0175_ sky130_fd_sc_hd__inv_2
XFILLER_82_401 VGND VGND VPWR VPWR sky130_fd_sc_hd__fill_2
X_3145_ net113 net111 net154 net152 VGND VGND VPWR VPWR _1066_ sky130_fd_sc_hd__nand4_1
XFILLER_27_317 VGND VGND VPWR VPWR sky130_fd_sc_hd__decap_4
X_3076_ net106 systolic_unit_0.U_00.out_b\[6\] net152 net108 VGND VGND VPWR VPWR _0997_
+ sky130_fd_sc_hd__a22oi_1
XFILLER_27_328 VGND VGND VPWR VPWR sky130_fd_sc_hd__decap_8
XFILLER_54_136 VGND VGND VPWR VPWR sky130_fd_sc_hd__decap_4
XFILLER_82_489 VPWR VGND VPWR VGND sky130_ef_sc_hd__decap_12
XFILLER_24_27 VGND VGND VPWR VPWR sky130_fd_sc_hd__fill_1
XFILLER_50_342 VPWR VGND VPWR VGND sky130_ef_sc_hd__decap_12
X_3978_ systolic_unit_0.U_11.acc_1\[5\] net74 net81 systolic_unit_0.U_01.acc_1\[5\]
+ VGND VGND VPWR VPWR _1841_ sky130_fd_sc_hd__a22o_1
X_2929_ net177 net175 net126 net124 VGND VGND VPWR VPWR _0882_ sky130_fd_sc_hd__and4_1
XFILLER_49_57 VPWR VGND VPWR VGND sky130_ef_sc_hd__decap_12
XFILLER_92_209 VPWR VGND VPWR VGND sky130_ef_sc_hd__decap_12
XTAP_TAPCELL_ROW_76_919 VGND VPWR sky130_fd_sc_hd__tapvpwrvgnd_1
XTAP_TAPCELL_ROW_86_1015 VGND VPWR sky130_fd_sc_hd__tapvpwrvgnd_1
XFILLER_73_412 VGND VGND VPWR VPWR sky130_fd_sc_hd__fill_1
XTAP_TAPCELL_ROW_84_996 VGND VPWR sky130_fd_sc_hd__tapvpwrvgnd_1
XFILLER_73_489 VPWR VGND VPWR VGND sky130_ef_sc_hd__decap_12
XFILLER_14_545 VGND VGND VPWR VPWR sky130_fd_sc_hd__decap_8
XFILLER_5_287 VGND VGND VPWR VPWR sky130_fd_sc_hd__fill_1
XFILLER_49_431 VPWR VGND VPWR VGND sky130_ef_sc_hd__decap_12
Xinput8 D_a_00[7] VGND VGND VPWR VPWR net8 sky130_fd_sc_hd__clkbuf_1
XFILLER_49_475 VPWR VGND VPWR VGND sky130_ef_sc_hd__decap_12
XFILLER_24_309 VPWR VGND VPWR VGND sky130_ef_sc_hd__decap_12
XFILLER_36_136 VGND VGND VPWR VPWR sky130_fd_sc_hd__decap_4
XFILLER_17_361 VGND VGND VPWR VPWR sky130_fd_sc_hd__decap_4
XTAP_TAPCELL_ROW_19_378 VGND VPWR sky130_fd_sc_hd__tapvpwrvgnd_1
X_3901_ _1463_ _1776_ VGND VGND VPWR VPWR _1789_ sky130_fd_sc_hd__xnor2_1
X_3832_ net203 net188 _1709_ VGND VGND VPWR VPWR _1721_ sky130_fd_sc_hd__a21oi_1
X_3763_ _1631_ _1651_ VGND VGND VPWR VPWR _1652_ sky130_fd_sc_hd__or2_1
X_2714_ _0641_ _0642_ VGND VGND VPWR VPWR _0667_ sky130_fd_sc_hd__xnor2_1
X_3694_ net187 net195 _1582_ _1580_ VGND VGND VPWR VPWR _1583_ sky130_fd_sc_hd__a31o_1
X_2645_ _0592_ _0597_ VGND VGND VPWR VPWR _0598_ sky130_fd_sc_hd__xnor2_1
XFILLER_10_29 VPWR VGND VPWR VGND sky130_ef_sc_hd__decap_12
X_2576_ _0559_ _0560_ VGND VGND VPWR VPWR _0561_ sky130_fd_sc_hd__xnor2_1
X_4315_ clknet_leaf_31_clk _0296_ _0039_ VGND VGND VPWR VPWR systolic_unit_0.U_10.acc_1\[7\]
+ sky130_fd_sc_hd__dfrtp_1
X_4246_ net241 VGND VGND VPWR VPWR _0227_ sky130_fd_sc_hd__inv_2
XFILLER_19_27 VPWR VGND VPWR VGND sky130_ef_sc_hd__decap_12
XFILLER_74_209 VPWR VGND VPWR VGND sky130_ef_sc_hd__decap_12
X_4177_ net241 VGND VGND VPWR VPWR _0158_ sky130_fd_sc_hd__inv_2
XTAP_TAPCELL_ROW_2_224 VGND VPWR sky130_fd_sc_hd__tapvpwrvgnd_1
XFILLER_27_125 VGND VGND VPWR VPWR sky130_fd_sc_hd__decap_6
X_3128_ systolic_unit_0.U_10.acc_1\[11\] systolic_unit_0.U_10.acc_0\[11\] net132 VGND
+ VGND VPWR VPWR _1049_ sky130_fd_sc_hd__mux2_1
XFILLER_67_272 VGND VGND VPWR VPWR sky130_fd_sc_hd__decap_8
XFILLER_67_294 VGND VGND VPWR VPWR sky130_fd_sc_hd__decap_3
XFILLER_27_158 VGND VGND VPWR VPWR sky130_fd_sc_hd__decap_4
XFILLER_82_264 VGND VGND VPWR VPWR sky130_fd_sc_hd__decap_8
XFILLER_27_169 VPWR VGND VPWR VGND sky130_ef_sc_hd__decap_12
X_3059_ net153 net102 _0978_ VGND VGND VPWR VPWR _0980_ sky130_fd_sc_hd__nand3_1
XFILLER_35_26 VGND VGND VPWR VPWR sky130_fd_sc_hd__fill_2
XFILLER_55_478 VPWR VGND VPWR VGND sky130_ef_sc_hd__decap_12
XFILLER_50_194 VGND VGND VPWR VPWR sky130_fd_sc_hd__fill_2
XFILLER_2_213 VPWR VGND VPWR VGND sky130_ef_sc_hd__decap_12
XTAP_TAPCELL_ROW_92_1074 VGND VPWR sky130_fd_sc_hd__tapvpwrvgnd_1
XFILLER_93_529 VGND VGND VPWR VPWR sky130_fd_sc_hd__decap_3
XFILLER_76_55 VGND VGND VPWR VPWR sky130_fd_sc_hd__decap_8
XFILLER_58_283 VGND VGND VPWR VPWR sky130_fd_sc_hd__fill_1
XFILLER_46_445 VGND VGND VPWR VPWR sky130_fd_sc_hd__decap_4
XFILLER_73_264 VGND VGND VPWR VPWR sky130_fd_sc_hd__decap_4
XFILLER_92_65 VPWR VGND VPWR VGND sky130_ef_sc_hd__decap_12
XTAP_TAPCELL_ROW_44_624 VGND VPWR sky130_fd_sc_hd__tapvpwrvgnd_1
XFILLER_61_459 VPWR VGND VPWR VGND sky130_ef_sc_hd__decap_12
X_2430_ _2090_ _2116_ _2128_ VGND VGND VPWR VPWR _2129_ sky130_fd_sc_hd__nand3_1
X_2361_ _2017_ _2018_ _2019_ VGND VGND VPWR VPWR _2060_ sky130_fd_sc_hd__a21oi_1
X_2292_ _1980_ _1990_ VGND VGND VPWR VPWR _1991_ sky130_fd_sc_hd__nand2_1
X_4100_ net248 VGND VGND VPWR VPWR _0081_ sky130_fd_sc_hd__inv_2
XFILLER_2_41 VPWR VGND VPWR VGND sky130_ef_sc_hd__decap_12
X_4031_ net250 VGND VGND VPWR VPWR _0012_ sky130_fd_sc_hd__inv_2
XFILLER_56_209 VPWR VGND VPWR VGND sky130_ef_sc_hd__decap_12
XFILLER_2_85 VPWR VGND VPWR VGND sky130_ef_sc_hd__decap_12
XFILLER_17_180 VPWR VGND VPWR VGND sky130_ef_sc_hd__decap_12
XFILLER_20_312 VGND VGND VPWR VPWR sky130_fd_sc_hd__decap_8
X_3815_ _1684_ _1685_ VGND VGND VPWR VPWR _1704_ sky130_fd_sc_hd__xnor2_2
X_3746_ _1632_ _1634_ VGND VGND VPWR VPWR _1635_ sky130_fd_sc_hd__and2_1
X_3677_ _1560_ _1565_ VGND VGND VPWR VPWR _1566_ sky130_fd_sc_hd__xnor2_1
X_2628_ net99 _0577_ net79 net413 VGND VGND VPWR VPWR _0362_ sky130_fd_sc_hd__a22o_1
XFILLER_87_301 VGND VGND VPWR VPWR sky130_fd_sc_hd__fill_2
X_2559_ _1960_ _0543_ VGND VGND VPWR VPWR _0544_ sky130_fd_sc_hd__nand2b_1
X_4229_ net240 VGND VGND VPWR VPWR _0210_ sky130_fd_sc_hd__inv_2
XFILLER_75_529 VPWR VGND VPWR VGND sky130_ef_sc_hd__decap_12
XTAP_TAPCELL_ROW_58_749 VGND VPWR sky130_fd_sc_hd__tapvpwrvgnd_1
XFILLER_15_139 VGND VGND VPWR VPWR sky130_fd_sc_hd__decap_3
XTAP_TAPCELL_ROW_13_329 VGND VPWR sky130_fd_sc_hd__tapvpwrvgnd_1
XFILLER_23_150 VGND VGND VPWR VPWR sky130_fd_sc_hd__fill_2
XFILLER_62_57 VPWR VGND VPWR VGND sky130_ef_sc_hd__decap_12
XFILLER_11_345 VPWR VGND VPWR VGND sky130_ef_sc_hd__decap_12
XFILLER_7_349 VGND VGND VPWR VPWR sky130_fd_sc_hd__decap_3
XFILLER_11_50 VGND VGND VPWR VPWR sky130_fd_sc_hd__decap_6
XFILLER_78_301 VGND VGND VPWR VPWR sky130_fd_sc_hd__decap_6
XFILLER_93_337 VGND VGND VPWR VPWR sky130_fd_sc_hd__fill_2
XFILLER_19_445 VGND VGND VPWR VPWR sky130_fd_sc_hd__decap_3
XTAP_TAPCELL_ROW_29_473 VGND VPWR sky130_fd_sc_hd__tapvpwrvgnd_1
XFILLER_34_459 VGND VGND VPWR VPWR sky130_fd_sc_hd__decap_8
XFILLER_61_256 VPWR VGND VPWR VGND sky130_ef_sc_hd__decap_12
Xinput22 D_b_00[5] VGND VGND VPWR VPWR net22 sky130_fd_sc_hd__buf_1
Xinput11 D_a_10[2] VGND VGND VPWR VPWR net11 sky130_fd_sc_hd__clkbuf_1
X_3600_ _1478_ _1488_ VGND VGND VPWR VPWR _1489_ sky130_fd_sc_hd__or2_1
Xinput33 a_ready VGND VGND VPWR VPWR net33 sky130_fd_sc_hd__clkbuf_1
X_3531_ _1321_ _1399_ net134 VGND VGND VPWR VPWR _1421_ sky130_fd_sc_hd__a21o_1
X_3462_ systolic_unit_0.U_00.acc_0\[8\] net206 net136 VGND VGND VPWR VPWR _1376_ sky130_fd_sc_hd__a21o_1
XFILLER_88_109 VPWR VGND VPWR VGND sky130_ef_sc_hd__decap_12
XFILLER_69_301 VGND VGND VPWR VPWR sky130_fd_sc_hd__decap_3
X_3393_ net116 net160 _1312_ _1310_ VGND VGND VPWR VPWR _1314_ sky130_fd_sc_hd__a31o_1
X_2413_ _2110_ _2111_ VGND VGND VPWR VPWR _2112_ sky130_fd_sc_hd__nand2_1
XFILLER_69_323 VPWR VGND VPWR VGND sky130_ef_sc_hd__decap_12
X_2344_ _2040_ _2041_ _2039_ VGND VGND VPWR VPWR _2043_ sky130_fd_sc_hd__o21bai_1
XFILLER_84_315 VPWR VGND VPWR VGND sky130_ef_sc_hd__decap_12
X_2275_ _1971_ _1973_ _1963_ VGND VGND VPWR VPWR _1974_ sky130_fd_sc_hd__o21ai_1
X_4014_ row_count\[0\] _1850_ VGND VGND VPWR VPWR _0270_ sky130_fd_sc_hd__and2b_1
XFILLER_65_540 VPWR VGND VPWR VGND sky130_ef_sc_hd__decap_12
XFILLER_37_297 VPWR VGND VPWR VGND sky130_ef_sc_hd__decap_12
XFILLER_52_234 VGND VGND VPWR VPWR sky130_fd_sc_hd__decap_8
XFILLER_12_109 VGND VGND VPWR VPWR sky130_fd_sc_hd__decap_3
XFILLER_33_470 VPWR VGND VPWR VGND sky130_ef_sc_hd__decap_12
XFILLER_52_289 VGND VGND VPWR VPWR sky130_fd_sc_hd__decap_6
XTAP_TAPCELL_ROW_63_796 VGND VPWR sky130_fd_sc_hd__tapvpwrvgnd_1
XFILLER_20_153 VGND VGND VPWR VPWR sky130_fd_sc_hd__decap_6
XFILLER_20_197 VGND VGND VPWR VPWR sky130_fd_sc_hd__fill_2
X_3729_ net187 net196 VGND VGND VPWR VPWR _1618_ sky130_fd_sc_hd__nand2_1
XFILLER_57_57 VGND VGND VPWR VPWR sky130_fd_sc_hd__decap_4
XFILLER_28_297 VGND VGND VPWR VPWR sky130_fd_sc_hd__decap_8
XFILLER_11_131 VGND VGND VPWR VPWR sky130_fd_sc_hd__decap_4
XFILLER_11_120 VGND VGND VPWR VPWR sky130_fd_sc_hd__decap_4
XFILLER_24_492 VGND VGND VPWR VPWR sky130_fd_sc_hd__decap_4
XFILLER_11_142 VGND VGND VPWR VPWR sky130_fd_sc_hd__decap_8
XFILLER_7_113 VPWR VGND VPWR VGND sky130_ef_sc_hd__decap_12
X_2962_ _0911_ _0914_ VGND VGND VPWR VPWR _0915_ sky130_fd_sc_hd__nand2_1
X_2893_ systolic_unit_0.U_01.acc_1\[3\] systolic_unit_0.U_01.acc_0\[3\] net138 VGND
+ VGND VPWR VPWR _0846_ sky130_fd_sc_hd__mux2_1
X_3514_ net96 _1373_ _1412_ VGND VGND VPWR VPWR _0298_ sky130_fd_sc_hd__a21o_1
X_4494_ clknet_leaf_32_clk net307 _0218_ VGND VGND VPWR VPWR systolic_unit_0.out_acc_0_r1\[9\]
+ sky130_fd_sc_hd__dfrtp_1
X_3445_ net303 _1356_ _1361_ _1362_ VGND VGND VPWR VPWR _0317_ sky130_fd_sc_hd__a22o_1
X_3376_ _1292_ _1296_ VGND VGND VPWR VPWR _1297_ sky130_fd_sc_hd__and2_1
X_2327_ _1989_ _2001_ _2014_ VGND VGND VPWR VPWR _2026_ sky130_fd_sc_hd__a21o_1
XFILLER_69_186 VPWR VGND VPWR VGND sky130_ef_sc_hd__decap_12
X_2258_ _1951_ _1956_ VGND VGND VPWR VPWR _1957_ sky130_fd_sc_hd__nand2_1
XTAP_TAPCELL_ROW_68_844 VGND VPWR sky130_fd_sc_hd__tapvpwrvgnd_1
XFILLER_72_307 VGND VGND VPWR VPWR sky130_fd_sc_hd__fill_1
XFILLER_84_189 VGND VGND VPWR VPWR sky130_fd_sc_hd__decap_6
X_2189_ net338 _1894_ net91 VGND VGND VPWR VPWR _0391_ sky130_fd_sc_hd__mux2_1
XFILLER_13_429 VPWR VGND VPWR VGND sky130_ef_sc_hd__decap_12
XFILLER_25_289 VGND VGND VPWR VPWR sky130_fd_sc_hd__decap_6
XFILLER_43_15 VGND VGND VPWR VPWR sky130_fd_sc_hd__fill_1
XTAP_TAPCELL_ROW_23_424 VGND VPWR sky130_fd_sc_hd__tapvpwrvgnd_1
XFILLER_0_300 VGND VGND VPWR VPWR sky130_fd_sc_hd__decap_4
XFILLER_0_377 VGND VGND VPWR VPWR sky130_fd_sc_hd__decap_4
XTAP_TAPCELL_ROW_89_1046 VGND VPWR sky130_fd_sc_hd__tapvpwrvgnd_1
XFILLER_84_77 VGND VGND VPWR VPWR sky130_fd_sc_hd__decap_6
XFILLER_44_510 VPWR VGND VPWR VGND sky130_ef_sc_hd__decap_12
XFILLER_31_237 VPWR VGND VPWR VGND sky130_ef_sc_hd__decap_12
XFILLER_8_433 VPWR VGND VPWR VGND sky130_ef_sc_hd__decap_12
XFILLER_33_92 VPWR VGND VPWR VGND sky130_ef_sc_hd__decap_12
XFILLER_8_477 VPWR VGND VPWR VGND sky130_ef_sc_hd__decap_12
X_3230_ _1145_ _1150_ VGND VGND VPWR VPWR _1151_ sky130_fd_sc_hd__nand2b_1
X_3161_ systolic_unit_0.U_10.acc_1\[10\] systolic_unit_0.U_10.acc_0\[10\] net132 VGND
+ VGND VPWR VPWR _1082_ sky130_fd_sc_hd__mux2_1
XFILLER_39_337 VGND VGND VPWR VPWR sky130_fd_sc_hd__fill_2
X_3092_ _0998_ _1012_ VGND VGND VPWR VPWR _1013_ sky130_fd_sc_hd__nor2_1
XFILLER_54_307 VGND VGND VPWR VPWR sky130_fd_sc_hd__fill_1
XFILLER_54_318 VGND VGND VPWR VPWR sky130_fd_sc_hd__decap_4
XFILLER_35_532 VPWR VGND VPWR VGND sky130_ef_sc_hd__decap_12
XTAP_TAPCELL_ROW_37_549 VGND VPWR sky130_fd_sc_hd__tapvpwrvgnd_1
XFILLER_47_370 VPWR VGND VPWR VGND sky130_ef_sc_hd__decap_12
XFILLER_62_362 VGND VGND VPWR VPWR sky130_fd_sc_hd__fill_2
XTAP_TAPCELL_ROW_73_891 VGND VPWR sky130_fd_sc_hd__tapvpwrvgnd_1
X_3994_ drain_odd _1847_ VGND VGND VPWR VPWR _0264_ sky130_fd_sc_hd__and2_1
X_2945_ _0895_ _0897_ VGND VGND VPWR VPWR _0898_ sky130_fd_sc_hd__nor2_1
X_2876_ _0825_ _0826_ VGND VGND VPWR VPWR _0829_ sky130_fd_sc_hd__xnor2_2
XFILLER_89_237 VPWR VGND VPWR VGND sky130_ef_sc_hd__decap_12
X_4477_ clknet_leaf_31_clk net318 _0201_ VGND VGND VPWR VPWR systolic_unit_0.out_acc_1_r1\[8\]
+ sky130_fd_sc_hd__dfrtp_1
X_3428_ _0980_ _1348_ VGND VGND VPWR VPWR _1349_ sky130_fd_sc_hd__xnor2_1
XFILLER_85_410 VPWR VGND VPWR VGND sky130_ef_sc_hd__decap_12
X_3359_ net280 _1277_ _1278_ VGND VGND VPWR VPWR _1280_ sky130_fd_sc_hd__nand3_1
XFILLER_38_26 VGND VGND VPWR VPWR sky130_fd_sc_hd__fill_2
XFILLER_38_370 VPWR VGND VPWR VGND sky130_ef_sc_hd__decap_12
XTAP_TAPCELL_ROW_0_196 VGND VPWR sky130_fd_sc_hd__tapvpwrvgnd_1
XFILLER_5_447 VGND VGND VPWR VPWR sky130_fd_sc_hd__fill_1
XFILLER_79_33 VGND VGND VPWR VPWR sky130_fd_sc_hd__fill_1
XTAP_TAPCELL_ROW_8_274 VGND VPWR sky130_fd_sc_hd__tapvpwrvgnd_1
XFILLER_0_141 VPWR VGND VPWR VGND sky130_ef_sc_hd__decap_12
XFILLER_48_101 VGND VGND VPWR VPWR sky130_fd_sc_hd__fill_1
XFILLER_76_421 VPWR VGND VPWR VGND sky130_ef_sc_hd__decap_12
XFILLER_48_134 VGND VGND VPWR VPWR sky130_fd_sc_hd__decap_6
XFILLER_91_413 VGND VGND VPWR VPWR sky130_fd_sc_hd__fill_1
XFILLER_44_362 VGND VGND VPWR VPWR sky130_fd_sc_hd__fill_2
X_2730_ _0681_ _0682_ net174 net118 VGND VGND VPWR VPWR _0683_ sky130_fd_sc_hd__and4bb_1
XTAP_TAPCELL_ROW_42_596 VGND VPWR sky130_fd_sc_hd__tapvpwrvgnd_1
X_2661_ systolic_unit_0.U_01.acc_1\[11\] systolic_unit_0.U_01.acc_0\[11\] net139 VGND
+ VGND VPWR VPWR _0614_ sky130_fd_sc_hd__mux2_1
X_4400_ clknet_leaf_13_clk net122 _0124_ VGND VGND VPWR VPWR systolic_unit_0.U_01.out_b\[4\]
+ sky130_fd_sc_hd__dfrtp_4
X_2592_ _0571_ _0572_ VGND VGND VPWR VPWR _0573_ sky130_fd_sc_hd__or2_1
X_4331_ clknet_leaf_31_clk _0312_ _0055_ VGND VGND VPWR VPWR systolic_unit_0.U_10.acc_0\[7\]
+ sky130_fd_sc_hd__dfrtp_1
X_4262_ net239 VGND VGND VPWR VPWR _0243_ sky130_fd_sc_hd__inv_2
Xfanout209 switch_r1 VGND VGND VPWR VPWR net209 sky130_fd_sc_hd__buf_2
X_3213_ _1132_ _1133_ net160 net105 VGND VGND VPWR VPWR _1134_ sky130_fd_sc_hd__and4bb_1
XFILLER_79_281 VPWR VGND VPWR VGND sky130_ef_sc_hd__decap_12
X_4193_ net233 VGND VGND VPWR VPWR _0174_ sky130_fd_sc_hd__inv_2
XFILLER_67_421 VPWR VGND VPWR VGND sky130_ef_sc_hd__decap_12
X_3144_ net107 net155 _1036_ _1038_ VGND VGND VPWR VPWR _1065_ sky130_fd_sc_hd__a22o_1
XPHY_EDGE_ROW_19_Left_113 VGND VGND VPWR VPWR sky130_fd_sc_hd__decap_3
X_3075_ net108 net106 net154 net152 VGND VGND VPWR VPWR _0996_ sky130_fd_sc_hd__and4_1
XFILLER_39_178 VPWR VGND VPWR VGND sky130_ef_sc_hd__decap_12
XFILLER_82_457 VGND VGND VPWR VPWR sky130_fd_sc_hd__fill_1
X_3977_ net97 _1811_ _1840_ VGND VGND VPWR VPWR _0251_ sky130_fd_sc_hd__a21o_1
XFILLER_50_354 VGND VGND VPWR VPWR sky130_fd_sc_hd__fill_1
X_2928_ net175 net126 net124 net177 VGND VGND VPWR VPWR _0881_ sky130_fd_sc_hd__a22oi_1
XPHY_EDGE_ROW_28_Left_122 VGND VGND VPWR VPWR sky130_fd_sc_hd__decap_3
X_2859_ _0777_ _0807_ _0810_ VGND VGND VPWR VPWR _0812_ sky130_fd_sc_hd__nand3_1
XFILLER_49_47 VGND VGND VPWR VPWR sky130_fd_sc_hd__fill_1
XFILLER_49_69 VGND VGND VPWR VPWR sky130_fd_sc_hd__fill_1
XPHY_EDGE_ROW_37_Left_131 VGND VGND VPWR VPWR sky130_fd_sc_hd__decap_3
XFILLER_58_421 VPWR VGND VPWR VGND sky130_ef_sc_hd__decap_12
XTAP_TAPCELL_ROW_86_1016 VGND VPWR sky130_fd_sc_hd__tapvpwrvgnd_1
XTAP_TAPCELL_ROW_84_997 VGND VPWR sky130_fd_sc_hd__tapvpwrvgnd_1
XFILLER_53_181 VPWR VGND VPWR VGND sky130_ef_sc_hd__decap_12
XPHY_EDGE_ROW_46_Left_140 VGND VGND VPWR VPWR sky130_fd_sc_hd__decap_3
XFILLER_1_461 VPWR VGND VPWR VGND sky130_ef_sc_hd__decap_12
XFILLER_49_443 VGND VGND VPWR VPWR sky130_fd_sc_hd__decap_4
Xinput9 D_a_10[0] VGND VGND VPWR VPWR net9 sky130_fd_sc_hd__clkbuf_1
XTAP_TAPCELL_ROW_47_644 VGND VPWR sky130_fd_sc_hd__tapvpwrvgnd_1
XTAP_TAPCELL_ROW_19_379 VGND VPWR sky130_fd_sc_hd__tapvpwrvgnd_1
XFILLER_32_321 VGND VGND VPWR VPWR sky130_fd_sc_hd__decap_8
X_3900_ net98 _1783_ _1788_ net407 _1786_ VGND VGND VPWR VPWR _0288_ sky130_fd_sc_hd__o221a_1
X_3831_ _1703_ _1719_ VGND VGND VPWR VPWR _1720_ sky130_fd_sc_hd__xnor2_2
X_3762_ net202 systolic_unit_0.U_01.out_b\[5\] systolic_unit_0.U_01.out_b\[6\] net205
+ VGND VGND VPWR VPWR _1651_ sky130_fd_sc_hd__a22oi_1
X_2713_ _0657_ _0665_ VGND VGND VPWR VPWR _0666_ sky130_fd_sc_hd__nand2_1
X_3693_ _1578_ _1579_ VGND VGND VPWR VPWR _1582_ sky130_fd_sc_hd__xnor2_2
X_2644_ net121 net165 VGND VGND VPWR VPWR _0597_ sky130_fd_sc_hd__nand2_1
X_2575_ systolic_unit_0.U_00.acc_1\[15\] systolic_unit_0.U_00.acc_0\[15\] net211 VGND
+ VGND VPWR VPWR _0560_ sky130_fd_sc_hd__mux2_1
X_4314_ clknet_leaf_32_clk _0295_ _0038_ VGND VGND VPWR VPWR systolic_unit_0.U_10.acc_1\[6\]
+ sky130_fd_sc_hd__dfrtp_1
XFILLER_87_505 VPWR VGND VPWR VGND sky130_ef_sc_hd__decap_12
X_4245_ net243 VGND VGND VPWR VPWR _0226_ sky130_fd_sc_hd__inv_2
XFILLER_19_39 VPWR VGND VPWR VGND sky130_ef_sc_hd__decap_12
X_4176_ net244 VGND VGND VPWR VPWR _0157_ sky130_fd_sc_hd__inv_2
XTAP_TAPCELL_ROW_2_225 VGND VPWR sky130_fd_sc_hd__tapvpwrvgnd_1
X_3127_ _1047_ _1034_ VGND VGND VPWR VPWR _1048_ sky130_fd_sc_hd__and2b_1
XFILLER_27_148 VGND VGND VPWR VPWR sky130_fd_sc_hd__decap_3
X_3058_ net152 net102 VGND VGND VPWR VPWR _0979_ sky130_fd_sc_hd__nand2_1
XTAP_TAPCELL_ROW_81_967 VGND VPWR sky130_fd_sc_hd__tapvpwrvgnd_1
XFILLER_11_505 VPWR VGND VPWR VGND sky130_ef_sc_hd__decap_12
XFILLER_23_354 VPWR VGND VPWR VGND sky130_ef_sc_hd__decap_12
XFILLER_2_225 VGND VGND VPWR VPWR sky130_fd_sc_hd__fill_2
XTAP_TAPCELL_ROW_92_1075 VGND VPWR sky130_fd_sc_hd__tapvpwrvgnd_1
XFILLER_58_262 VGND VGND VPWR VPWR sky130_fd_sc_hd__fill_1
XFILLER_73_287 VGND VGND VPWR VPWR sky130_fd_sc_hd__decap_8
XFILLER_92_77 VGND VGND VPWR VPWR sky130_fd_sc_hd__decap_6
XTAP_TAPCELL_ROW_16_349 VGND VPWR sky130_fd_sc_hd__tapvpwrvgnd_1
XFILLER_14_365 VPWR VGND VPWR VGND sky130_ef_sc_hd__decap_12
XFILLER_41_140 VPWR VGND VPWR VGND sky130_ef_sc_hd__decap_12
XTAP_TAPCELL_ROW_52_691 VGND VPWR sky130_fd_sc_hd__tapvpwrvgnd_1
XFILLER_6_553 VGND VGND VPWR VPWR sky130_fd_sc_hd__fill_1
XFILLER_6_531 VGND VGND VPWR VPWR sky130_fd_sc_hd__fill_1
XFILLER_69_505 VPWR VGND VPWR VGND sky130_ef_sc_hd__decap_12
X_2360_ _2045_ _2048_ _2046_ VGND VGND VPWR VPWR _2059_ sky130_fd_sc_hd__o21a_1
X_2291_ _1987_ _1989_ VGND VGND VPWR VPWR _1990_ sky130_fd_sc_hd__nand2_1
XPHY_EDGE_ROW_10_Right_10 VGND VGND VPWR VPWR sky130_fd_sc_hd__decap_3
XFILLER_2_53 VPWR VGND VPWR VGND sky130_ef_sc_hd__decap_12
X_4030_ net248 VGND VGND VPWR VPWR _0011_ sky130_fd_sc_hd__inv_2
XFILLER_37_413 VPWR VGND VPWR VGND sky130_ef_sc_hd__decap_12
XFILLER_2_97 VPWR VGND VPWR VGND sky130_ef_sc_hd__decap_12
XFILLER_64_221 VGND VGND VPWR VPWR sky130_fd_sc_hd__decap_4
XFILLER_52_416 VGND VGND VPWR VPWR sky130_fd_sc_hd__decap_4
XFILLER_64_276 VGND VGND VPWR VPWR sky130_fd_sc_hd__decap_6
XFILLER_17_192 VGND VGND VPWR VPWR sky130_fd_sc_hd__decap_4
X_3814_ net204 net203 net186 net183 VGND VGND VPWR VPWR _1703_ sky130_fd_sc_hd__and4_1
X_3745_ _1596_ _1633_ VGND VGND VPWR VPWR _1634_ sky130_fd_sc_hd__nor2_1
X_3676_ _1563_ _1564_ VGND VGND VPWR VPWR _1565_ sky130_fd_sc_hd__nor2_1
X_2627_ net99 _0575_ net79 net390 VGND VGND VPWR VPWR _0363_ sky130_fd_sc_hd__a22o_1
X_2558_ _0541_ _0542_ VGND VGND VPWR VPWR _0543_ sky130_fd_sc_hd__and2_1
X_2489_ net271 net266 net255 net272 VGND VGND VPWR VPWR _0474_ sky130_fd_sc_hd__a22oi_1
X_4228_ net240 VGND VGND VPWR VPWR _0209_ sky130_fd_sc_hd__inv_2
XFILLER_83_541 VPWR VGND VPWR VGND sky130_ef_sc_hd__decap_12
X_4159_ net232 VGND VGND VPWR VPWR _0140_ sky130_fd_sc_hd__inv_2
XFILLER_55_210 VPWR VGND VPWR VGND sky130_ef_sc_hd__decap_12
XFILLER_55_243 VPWR VGND VPWR VGND sky130_ef_sc_hd__decap_12
XFILLER_28_468 VGND VGND VPWR VPWR sky130_fd_sc_hd__fill_1
XFILLER_15_118 VPWR VGND VPWR VGND sky130_ef_sc_hd__decap_12
XFILLER_36_490 VGND VGND VPWR VPWR sky130_fd_sc_hd__fill_2
XFILLER_62_69 VPWR VGND VPWR VGND sky130_ef_sc_hd__decap_12
XFILLER_11_357 VGND VGND VPWR VPWR sky130_fd_sc_hd__decap_6
XFILLER_11_379 VPWR VGND VPWR VGND sky130_ef_sc_hd__decap_12
XFILLER_11_84 VGND VGND VPWR VPWR sky130_fd_sc_hd__decap_3
XFILLER_87_55 VGND VGND VPWR VPWR sky130_fd_sc_hd__fill_1
XFILLER_46_221 VGND VGND VPWR VPWR sky130_fd_sc_hd__fill_1
XTAP_TAPCELL_ROW_29_474 VGND VPWR sky130_fd_sc_hd__tapvpwrvgnd_1
XFILLER_61_235 VGND VGND VPWR VPWR sky130_fd_sc_hd__fill_2
Xclkbuf_leaf_26_clk clknet_2_1__leaf_clk VGND VGND VPWR VPWR clknet_leaf_26_clk sky130_fd_sc_hd__clkbuf_8
XFILLER_42_471 VGND VGND VPWR VPWR sky130_fd_sc_hd__decap_4
XFILLER_61_279 VGND VGND VPWR VPWR sky130_fd_sc_hd__fill_1
XFILLER_14_184 VPWR VGND VPWR VGND sky130_ef_sc_hd__decap_12
Xinput12 D_a_10[3] VGND VGND VPWR VPWR net12 sky130_fd_sc_hd__clkbuf_1
Xinput34 b_ready VGND VGND VPWR VPWR net34 sky130_fd_sc_hd__clkbuf_1
X_3530_ net96 _1398_ _1420_ VGND VGND VPWR VPWR _0290_ sky130_fd_sc_hd__a21o_1
Xinput23 D_b_00[6] VGND VGND VPWR VPWR net23 sky130_fd_sc_hd__clkbuf_1
XFILLER_10_390 VPWR VGND VPWR VGND sky130_ef_sc_hd__decap_12
X_3461_ net133 _1374_ VGND VGND VPWR VPWR _1375_ sky130_fd_sc_hd__nand2_1
X_3392_ _1268_ _1310_ _1312_ VGND VGND VPWR VPWR _1313_ sky130_fd_sc_hd__or3b_1
X_2412_ _2016_ _2093_ VGND VGND VPWR VPWR _2111_ sky130_fd_sc_hd__xnor2_1
XFILLER_69_335 VGND VGND VPWR VPWR sky130_fd_sc_hd__fill_1
X_2343_ _2039_ _2040_ _2041_ VGND VGND VPWR VPWR _2042_ sky130_fd_sc_hd__or3_1
XFILLER_84_327 VPWR VGND VPWR VGND sky130_ef_sc_hd__decap_12
X_2274_ net218 net258 _1972_ VGND VGND VPWR VPWR _1973_ sky130_fd_sc_hd__and3_1
X_4013_ _1859_ _1860_ _1861_ _0000_ VGND VGND VPWR VPWR _0269_ sky130_fd_sc_hd__o211a_1
XFILLER_65_552 VGND VGND VPWR VPWR sky130_fd_sc_hd__fill_2
XFILLER_80_533 VPWR VGND VPWR VGND sky130_ef_sc_hd__decap_12
XFILLER_16_29 VGND VGND VPWR VPWR sky130_fd_sc_hd__decap_8
XFILLER_25_449 VGND VGND VPWR VPWR sky130_fd_sc_hd__decap_8
Xclkbuf_leaf_17_clk clknet_2_3__leaf_clk VGND VGND VPWR VPWR clknet_leaf_17_clk sky130_fd_sc_hd__clkbuf_8
XFILLER_33_482 VPWR VGND VPWR VGND sky130_ef_sc_hd__decap_12
XTAP_TAPCELL_ROW_63_797 VGND VPWR sky130_fd_sc_hd__tapvpwrvgnd_1
XFILLER_4_309 VPWR VGND VPWR VGND sky130_ef_sc_hd__decap_12
X_3728_ net189 net195 _1615_ VGND VGND VPWR VPWR _1617_ sky130_fd_sc_hd__and3_1
X_3659_ net185 net194 _1472_ VGND VGND VPWR VPWR _1548_ sky130_fd_sc_hd__nand3_1
XFILLER_75_327 VGND VGND VPWR VPWR sky130_fd_sc_hd__fill_1
XFILLER_57_69 VPWR VGND VPWR VGND sky130_ef_sc_hd__decap_12
XFILLER_28_243 VGND VGND VPWR VPWR sky130_fd_sc_hd__decap_8
XFILLER_83_393 VGND VGND VPWR VPWR sky130_fd_sc_hd__fill_1
XFILLER_28_276 VGND VGND VPWR VPWR sky130_fd_sc_hd__fill_1
XFILLER_73_57 VPWR VGND VPWR VGND sky130_ef_sc_hd__decap_12
XTAP_TAPCELL_ROW_26_444 VGND VPWR sky130_fd_sc_hd__tapvpwrvgnd_1
XFILLER_11_165 VGND VGND VPWR VPWR sky130_fd_sc_hd__decap_3
XFILLER_7_125 VGND VGND VPWR VPWR sky130_fd_sc_hd__decap_8
XFILLER_93_113 VPWR VGND VPWR VGND sky130_ef_sc_hd__decap_12
XFILLER_78_154 VPWR VGND VPWR VGND sky130_ef_sc_hd__decap_12
XFILLER_14_7 VPWR VGND VPWR VGND sky130_ef_sc_hd__decap_12
XFILLER_47_530 VGND VGND VPWR VPWR sky130_fd_sc_hd__decap_4
XFILLER_34_213 VGND VGND VPWR VPWR sky130_fd_sc_hd__fill_1
XFILLER_62_533 VPWR VGND VPWR VGND sky130_ef_sc_hd__decap_12
XFILLER_34_235 VGND VGND VPWR VPWR sky130_fd_sc_hd__decap_3
XFILLER_22_419 VGND VGND VPWR VPWR sky130_fd_sc_hd__fill_1
X_2961_ _0913_ VGND VGND VPWR VPWR _0914_ sky130_fd_sc_hd__inv_2
X_2892_ _0828_ _0829_ VGND VGND VPWR VPWR _0845_ sky130_fd_sc_hd__xnor2_2
XFILLER_8_41 VPWR VGND VPWR VGND sky130_ef_sc_hd__decap_12
XTAP_TAPCELL_ROW_60_767 VGND VPWR sky130_fd_sc_hd__tapvpwrvgnd_1
XFILLER_8_85 VGND VGND VPWR VPWR sky130_fd_sc_hd__fill_1
XFILLER_30_485 VGND VGND VPWR VPWR sky130_fd_sc_hd__decap_4
X_4493_ clknet_leaf_31_clk net309 _0217_ VGND VGND VPWR VPWR systolic_unit_0.out_acc_0_r1\[8\]
+ sky130_fd_sc_hd__dfrtp_1
X_3513_ systolic_unit_0.U_10.acc_1\[9\] net76 net83 systolic_unit_0.U_00.acc_1\[9\]
+ VGND VGND VPWR VPWR _1412_ sky130_fd_sc_hd__a22o_1
X_3444_ systolic_unit_0.U_00.acc_0\[12\] net206 net136 VGND VGND VPWR VPWR _1362_
+ sky130_fd_sc_hd__a21o_1
Xclkbuf_leaf_6_clk clknet_2_0__leaf_clk VGND VGND VPWR VPWR clknet_leaf_6_clk sky130_fd_sc_hd__clkbuf_8
XFILLER_69_132 VPWR VGND VPWR VGND sky130_ef_sc_hd__decap_12
X_3375_ _1292_ _1294_ _1295_ VGND VGND VPWR VPWR _1296_ sky130_fd_sc_hd__nand3_1
X_2326_ _2021_ _2023_ VGND VGND VPWR VPWR _2025_ sky130_fd_sc_hd__xnor2_1
X_2257_ _1953_ _1955_ _1952_ VGND VGND VPWR VPWR _1956_ sky130_fd_sc_hd__a21bo_1
XFILLER_69_198 VPWR VGND VPWR VGND sky130_ef_sc_hd__decap_12
XTAP_TAPCELL_ROW_68_845 VGND VPWR sky130_fd_sc_hd__tapvpwrvgnd_1
XFILLER_27_39 VGND VGND VPWR VPWR sky130_fd_sc_hd__decap_4
X_2188_ systolic_unit_0.U_11.acc_0\[6\] systolic_unit_0.U_11.acc_1\[6\] net150 VGND
+ VGND VPWR VPWR _1894_ sky130_fd_sc_hd__mux2_1
XFILLER_53_533 VGND VGND VPWR VPWR sky130_fd_sc_hd__fill_1
XFILLER_65_393 VGND VGND VPWR VPWR sky130_fd_sc_hd__decap_6
XFILLER_40_216 VGND VGND VPWR VPWR sky130_fd_sc_hd__fill_1
XFILLER_33_290 VGND VGND VPWR VPWR sky130_fd_sc_hd__decap_8
XFILLER_40_249 VGND VGND VPWR VPWR sky130_fd_sc_hd__decap_3
XFILLER_4_117 VGND VGND VPWR VPWR sky130_fd_sc_hd__decap_3
XFILLER_4_139 VGND VGND VPWR VPWR sky130_fd_sc_hd__fill_1
XFILLER_88_463 VPWR VGND VPWR VGND sky130_ef_sc_hd__decap_12
XFILLER_0_356 VGND VGND VPWR VPWR sky130_fd_sc_hd__decap_4
XFILLER_75_135 VPWR VGND VPWR VGND sky130_ef_sc_hd__decap_12
XFILLER_75_113 VGND VGND VPWR VPWR sky130_fd_sc_hd__fill_1
XTAP_TAPCELL_ROW_89_1047 VGND VPWR sky130_fd_sc_hd__tapvpwrvgnd_1
XFILLER_29_552 VGND VGND VPWR VPWR sky130_fd_sc_hd__fill_2
XFILLER_44_522 VGND VGND VPWR VPWR sky130_fd_sc_hd__decap_8
XFILLER_44_533 VGND VGND VPWR VPWR sky130_fd_sc_hd__decap_6
XFILLER_31_205 VPWR VGND VPWR VGND sky130_ef_sc_hd__decap_12
XFILLER_31_249 VGND VGND VPWR VPWR sky130_fd_sc_hd__decap_6
XFILLER_33_60 VPWR VGND VPWR VGND sky130_ef_sc_hd__decap_12
XFILLER_8_445 VPWR VGND VPWR VGND sky130_ef_sc_hd__decap_12
XFILLER_8_489 VPWR VGND VPWR VGND sky130_ef_sc_hd__decap_12
XFILLER_3_183 VGND VGND VPWR VPWR sky130_fd_sc_hd__decap_3
X_3160_ net160 net101 _1073_ _1072_ VGND VGND VPWR VPWR _1081_ sky130_fd_sc_hd__a31o_1
XFILLER_39_305 VGND VGND VPWR VPWR sky130_fd_sc_hd__fill_1
X_3091_ systolic_unit_0.U_00.out_b\[5\] net103 _0996_ _0997_ VGND VGND VPWR VPWR _1012_
+ sky130_fd_sc_hd__o2bb2a_1
XTAP_TAPCELL_ROW_65_815 VGND VPWR sky130_fd_sc_hd__tapvpwrvgnd_1
XFILLER_81_138 VPWR VGND VPWR VGND sky130_ef_sc_hd__decap_12
XFILLER_81_105 VGND VGND VPWR VPWR sky130_fd_sc_hd__decap_6
XFILLER_47_382 VGND VGND VPWR VPWR sky130_fd_sc_hd__decap_8
XFILLER_35_544 VGND VGND VPWR VPWR sky130_fd_sc_hd__decap_8
XFILLER_47_393 VPWR VGND VPWR VGND sky130_ef_sc_hd__decap_12
XPHY_EDGE_ROW_8_Right_8 VGND VGND VPWR VPWR sky130_fd_sc_hd__decap_3
XTAP_TAPCELL_ROW_73_892 VGND VPWR sky130_fd_sc_hd__tapvpwrvgnd_1
X_3993_ net210 _1847_ VGND VGND VPWR VPWR _0263_ sky130_fd_sc_hd__and2_1
X_2944_ net130 net175 _0894_ VGND VGND VPWR VPWR _0897_ sky130_fd_sc_hd__a21oi_1
X_2875_ net128 net171 VGND VGND VPWR VPWR _0828_ sky130_fd_sc_hd__nand2_1
XFILLER_89_205 VPWR VGND VPWR VGND sky130_ef_sc_hd__decap_12
X_4476_ clknet_leaf_31_clk net319 _0200_ VGND VGND VPWR VPWR systolic_unit_0.out_acc_1_r1\[7\]
+ sky130_fd_sc_hd__dfrtp_1
XFILLER_89_249 VPWR VGND VPWR VGND sky130_ef_sc_hd__decap_12
X_3427_ systolic_unit_0.U_10.acc_1\[15\] systolic_unit_0.U_10.acc_0\[15\] net134 VGND
+ VGND VPWR VPWR _1348_ sky130_fd_sc_hd__mux2_1
XPHY_EDGE_ROW_39_Right_39 VGND VGND VPWR VPWR sky130_fd_sc_hd__decap_3
X_3358_ _1276_ _1277_ _1278_ VGND VGND VPWR VPWR _1279_ sky130_fd_sc_hd__and3_1
XFILLER_57_102 VGND VGND VPWR VPWR sky130_fd_sc_hd__fill_1
XFILLER_85_422 VGND VGND VPWR VPWR sky130_fd_sc_hd__decap_8
X_2309_ _1985_ _2002_ _2007_ VGND VGND VPWR VPWR _2008_ sky130_fd_sc_hd__nand3_1
XFILLER_38_38 VGND VGND VPWR VPWR sky130_fd_sc_hd__decap_4
XFILLER_57_135 VPWR VGND VPWR VGND sky130_ef_sc_hd__decap_12
X_3289_ net111 net158 net156 net113 VGND VGND VPWR VPWR _1210_ sky130_fd_sc_hd__a22o_1
XFILLER_57_157 VGND VGND VPWR VPWR sky130_fd_sc_hd__decap_8
XFILLER_26_511 VPWR VGND VPWR VGND sky130_ef_sc_hd__decap_12
XFILLER_38_360 VGND VGND VPWR VPWR sky130_fd_sc_hd__decap_4
XFILLER_38_382 VPWR VGND VPWR VGND sky130_ef_sc_hd__decap_12
XFILLER_26_533 VPWR VGND VPWR VGND sky130_ef_sc_hd__decap_12
XFILLER_54_15 VPWR VGND VPWR VGND sky130_ef_sc_hd__decap_12
XFILLER_13_205 VGND VGND VPWR VPWR sky130_fd_sc_hd__fill_2
XTAP_TAPCELL_ROW_0_197 VGND VPWR sky130_fd_sc_hd__tapvpwrvgnd_1
XFILLER_41_525 VGND VGND VPWR VPWR sky130_fd_sc_hd__decap_6
XFILLER_53_374 VPWR VGND VPWR VGND sky130_ef_sc_hd__decap_12
XPHY_EDGE_ROW_48_Right_48 VGND VGND VPWR VPWR sky130_fd_sc_hd__decap_3
XFILLER_53_396 VGND VGND VPWR VPWR sky130_fd_sc_hd__decap_4
XFILLER_70_47 VGND VGND VPWR VPWR sky130_fd_sc_hd__fill_1
XPHY_EDGE_ROW_57_Right_57 VGND VGND VPWR VPWR sky130_fd_sc_hd__decap_3
XTAP_TAPCELL_ROW_8_275 VGND VPWR sky130_fd_sc_hd__tapvpwrvgnd_1
XFILLER_0_153 VPWR VGND VPWR VGND sky130_ef_sc_hd__decap_12
XFILLER_76_433 VPWR VGND VPWR VGND sky130_ef_sc_hd__decap_12
XFILLER_0_197 VPWR VGND VPWR VGND sky130_ef_sc_hd__decap_12
XFILLER_48_146 VPWR VGND VPWR VGND sky130_ef_sc_hd__decap_12
XFILLER_91_425 VPWR VGND VPWR VGND sky130_ef_sc_hd__decap_12
XFILLER_29_393 VPWR VGND VPWR VGND sky130_ef_sc_hd__decap_12
XFILLER_71_160 VGND VGND VPWR VPWR sky130_fd_sc_hd__decap_3
XPHY_EDGE_ROW_66_Right_66 VGND VGND VPWR VPWR sky130_fd_sc_hd__decap_3
XTAP_TAPCELL_ROW_70_862 VGND VPWR sky130_fd_sc_hd__tapvpwrvgnd_1
XTAP_TAPCELL_ROW_42_597 VGND VPWR sky130_fd_sc_hd__tapvpwrvgnd_1
X_2660_ _0608_ _0612_ VGND VGND VPWR VPWR _0613_ sky130_fd_sc_hd__and2_1
XFILLER_12_282 VPWR VGND VPWR VGND sky130_ef_sc_hd__decap_12
XFILLER_8_253 VGND VGND VPWR VPWR sky130_fd_sc_hd__fill_1
XPHY_EDGE_ROW_75_Right_75 VGND VGND VPWR VPWR sky130_fd_sc_hd__decap_3
X_2591_ _0537_ _0568_ _0570_ VGND VGND VPWR VPWR _0572_ sky130_fd_sc_hd__and3_1
X_4330_ clknet_leaf_32_clk _0311_ _0054_ VGND VGND VPWR VPWR systolic_unit_0.U_10.acc_0\[6\]
+ sky130_fd_sc_hd__dfrtp_1
X_4261_ net237 VGND VGND VPWR VPWR _0242_ sky130_fd_sc_hd__inv_2
XFILLER_5_97 VGND VGND VPWR VPWR sky130_fd_sc_hd__fill_1
X_3212_ net109 net156 net107 net158 VGND VGND VPWR VPWR _1133_ sky130_fd_sc_hd__a22oi_1
XFILLER_79_293 VPWR VGND VPWR VGND sky130_ef_sc_hd__decap_12
X_4192_ net233 VGND VGND VPWR VPWR _0173_ sky130_fd_sc_hd__inv_2
XFILLER_67_433 VPWR VGND VPWR VGND sky130_ef_sc_hd__decap_12
XTAP_TAPCELL_ROW_78_940 VGND VPWR sky130_fd_sc_hd__tapvpwrvgnd_1
X_3143_ _1046_ _1063_ VGND VGND VPWR VPWR _1064_ sky130_fd_sc_hd__nor2_1
XPHY_EDGE_ROW_84_Right_84 VGND VGND VPWR VPWR sky130_fd_sc_hd__decap_3
X_3074_ _0985_ _0986_ VGND VGND VPWR VPWR _0995_ sky130_fd_sc_hd__xnor2_1
XFILLER_23_503 VGND VGND VPWR VPWR sky130_fd_sc_hd__fill_1
XFILLER_50_300 VGND VGND VPWR VPWR sky130_fd_sc_hd__fill_1
XFILLER_24_29 VPWR VGND VPWR VGND sky130_ef_sc_hd__decap_12
X_3976_ systolic_unit_0.U_11.acc_1\[6\] net74 net81 systolic_unit_0.U_01.acc_1\[6\]
+ VGND VGND VPWR VPWR _1840_ sky130_fd_sc_hd__a22o_1
X_2927_ _0876_ _0879_ _0873_ VGND VGND VPWR VPWR _0880_ sky130_fd_sc_hd__o21a_1
XFILLER_10_208 VPWR VGND VPWR VGND sky130_ef_sc_hd__decap_12
XPHY_EDGE_ROW_93_Right_93 VGND VGND VPWR VPWR sky130_fd_sc_hd__decap_3
X_2858_ _0807_ _0810_ _0777_ VGND VGND VPWR VPWR _0811_ sky130_fd_sc_hd__a21oi_1
X_2789_ _0707_ _0708_ VGND VGND VPWR VPWR _0742_ sky130_fd_sc_hd__xnor2_1
XFILLER_2_407 VPWR VGND VPWR VGND sky130_ef_sc_hd__decap_12
X_4459_ clknet_leaf_31_clk _0408_ _0183_ VGND VGND VPWR VPWR net68 sky130_fd_sc_hd__dfrtp_1
XTAP_TAPCELL_ROW_5_245 VGND VPWR sky130_fd_sc_hd__tapvpwrvgnd_1
XFILLER_58_433 VGND VGND VPWR VPWR sky130_fd_sc_hd__decap_4
XTAP_TAPCELL_ROW_86_1017 VGND VPWR sky130_fd_sc_hd__tapvpwrvgnd_1
XFILLER_58_488 VGND VGND VPWR VPWR sky130_fd_sc_hd__decap_4
XFILLER_73_447 VGND VGND VPWR VPWR sky130_fd_sc_hd__fill_1
XTAP_TAPCELL_ROW_84_998 VGND VPWR sky130_fd_sc_hd__tapvpwrvgnd_1
XFILLER_53_193 VPWR VGND VPWR VGND sky130_ef_sc_hd__decap_12
XFILLER_81_57 VPWR VGND VPWR VGND sky130_ef_sc_hd__decap_12
XFILLER_41_344 VGND VGND VPWR VPWR sky130_fd_sc_hd__fill_2
XFILLER_5_223 VGND VGND VPWR VPWR sky130_fd_sc_hd__fill_1
XFILLER_30_83 VGND VGND VPWR VPWR sky130_fd_sc_hd__fill_1
XFILLER_1_473 VPWR VGND VPWR VGND sky130_ef_sc_hd__decap_12
XFILLER_49_422 VGND VGND VPWR VPWR sky130_fd_sc_hd__decap_6
XFILLER_39_92 VGND VGND VPWR VPWR sky130_fd_sc_hd__fill_2
XTAP_TAPCELL_ROW_75_910 VGND VPWR sky130_fd_sc_hd__tapvpwrvgnd_1
XFILLER_76_296 VGND VGND VPWR VPWR sky130_fd_sc_hd__fill_2
XTAP_TAPCELL_ROW_47_645 VGND VPWR sky130_fd_sc_hd__tapvpwrvgnd_1
XFILLER_20_506 VPWR VGND VPWR VGND sky130_ef_sc_hd__decap_12
X_3830_ _1704_ _1716_ VGND VGND VPWR VPWR _1719_ sky130_fd_sc_hd__xor2_2
X_3761_ net202 net182 _1648_ _1646_ VGND VGND VPWR VPWR _1650_ sky130_fd_sc_hd__a31o_1
X_2712_ _0646_ _0656_ VGND VGND VPWR VPWR _0665_ sky130_fd_sc_hd__nand2_1
X_3692_ net187 net195 VGND VGND VPWR VPWR _1581_ sky130_fd_sc_hd__nand2_1
X_2643_ _0594_ _0595_ VGND VGND VPWR VPWR _0596_ sky130_fd_sc_hd__nand2_1
X_2574_ net212 net257 _1913_ _1915_ VGND VGND VPWR VPWR _0559_ sky130_fd_sc_hd__a31o_1
X_4313_ clknet_leaf_29_clk _0294_ _0037_ VGND VGND VPWR VPWR systolic_unit_0.U_10.acc_1\[5\]
+ sky130_fd_sc_hd__dfrtp_1
XFILLER_87_517 VPWR VGND VPWR VGND sky130_ef_sc_hd__decap_12
X_4244_ net243 VGND VGND VPWR VPWR _0225_ sky130_fd_sc_hd__inv_2
X_4175_ net241 VGND VGND VPWR VPWR _0156_ sky130_fd_sc_hd__inv_2
X_3126_ _1044_ _1045_ _1041_ VGND VGND VPWR VPWR _1047_ sky130_fd_sc_hd__a21boi_1
XFILLER_55_447 VGND VGND VPWR VPWR sky130_fd_sc_hd__fill_1
X_3057_ systolic_unit_0.U_00.out_b\[6\] net104 VGND VGND VPWR VPWR _0978_ sky130_fd_sc_hd__and2_1
XTAP_TAPCELL_ROW_81_968 VGND VPWR sky130_fd_sc_hd__tapvpwrvgnd_1
XFILLER_23_366 VGND VGND VPWR VPWR sky130_fd_sc_hd__fill_2
XFILLER_50_141 VGND VGND VPWR VPWR sky130_fd_sc_hd__fill_1
XFILLER_11_517 VPWR VGND VPWR VGND sky130_ef_sc_hd__decap_12
X_3959_ net147 _1783_ _1831_ net432 _1829_ VGND VGND VPWR VPWR _0260_ sky130_fd_sc_hd__o221a_1
XTAP_TAPCELL_ROW_92_1076 VGND VPWR sky130_fd_sc_hd__tapvpwrvgnd_1
XFILLER_58_230 VPWR VGND VPWR VGND sky130_ef_sc_hd__decap_12
XFILLER_76_79 VGND VGND VPWR VPWR sky130_fd_sc_hd__fill_2
XFILLER_73_233 VGND VGND VPWR VPWR sky130_fd_sc_hd__fill_1
XFILLER_73_211 VPWR VGND VPWR VGND sky130_ef_sc_hd__decap_12
XFILLER_46_458 VPWR VGND VPWR VGND sky130_ef_sc_hd__decap_12
XTAP_TAPCELL_ROW_44_615 VGND VPWR sky130_fd_sc_hd__tapvpwrvgnd_1
XFILLER_14_377 VPWR VGND VPWR VGND sky130_ef_sc_hd__decap_12
XFILLER_41_152 VGND VGND VPWR VPWR sky130_fd_sc_hd__decap_4
XTAP_TAPCELL_ROW_52_692 VGND VPWR sky130_fd_sc_hd__tapvpwrvgnd_1
XFILLER_69_517 VPWR VGND VPWR VGND sky130_ef_sc_hd__decap_12
X_2290_ net220 net258 _1987_ _1988_ VGND VGND VPWR VPWR _1989_ sky130_fd_sc_hd__nand4_1
XFILLER_1_281 VGND VGND VPWR VPWR sky130_fd_sc_hd__decap_4
XFILLER_2_65 VPWR VGND VPWR VGND sky130_ef_sc_hd__decap_12
XFILLER_92_531 VGND VGND VPWR VPWR sky130_fd_sc_hd__fill_1
XFILLER_37_425 VPWR VGND VPWR VGND sky130_ef_sc_hd__decap_12
XFILLER_49_285 VGND VGND VPWR VPWR sky130_fd_sc_hd__fill_1
XFILLER_92_553 VGND VGND VPWR VPWR sky130_fd_sc_hd__fill_1
XFILLER_45_491 VGND VGND VPWR VPWR sky130_fd_sc_hd__decap_4
XFILLER_64_299 VGND VGND VPWR VPWR sky130_fd_sc_hd__decap_8
XFILLER_32_141 VPWR VGND VPWR VGND sky130_ef_sc_hd__decap_12
X_3813_ _1695_ _1700_ VGND VGND VPWR VPWR _1702_ sky130_fd_sc_hd__xnor2_1
X_3744_ net205 net178 _1595_ VGND VGND VPWR VPWR _1633_ sky130_fd_sc_hd__a21oi_1
X_3675_ _1547_ _1551_ _1562_ VGND VGND VPWR VPWR _1564_ sky130_fd_sc_hd__nor3_1
X_2626_ net99 _0573_ net79 net366 VGND VGND VPWR VPWR _0364_ sky130_fd_sc_hd__a22o_1
XPHY_EDGE_ROW_65_Left_159 VGND VGND VPWR VPWR sky130_fd_sc_hd__decap_3
X_2557_ _1974_ _1977_ _0540_ VGND VGND VPWR VPWR _0542_ sky130_fd_sc_hd__nand3_1
X_2488_ net272 net270 net266 net255 VGND VGND VPWR VPWR _0473_ sky130_fd_sc_hd__and4_1
X_4227_ net229 VGND VGND VPWR VPWR _0208_ sky130_fd_sc_hd__inv_2
XFILLER_28_414 VGND VGND VPWR VPWR sky130_fd_sc_hd__decap_6
XPHY_EDGE_ROW_74_Left_168 VGND VGND VPWR VPWR sky130_fd_sc_hd__decap_3
X_4158_ net225 VGND VGND VPWR VPWR _0139_ sky130_fd_sc_hd__inv_2
XFILLER_55_222 VGND VGND VPWR VPWR sky130_fd_sc_hd__fill_2
XFILLER_55_233 VGND VGND VPWR VPWR sky130_fd_sc_hd__decap_3
XFILLER_83_553 VGND VGND VPWR VPWR sky130_fd_sc_hd__fill_1
X_4089_ net239 VGND VGND VPWR VPWR _0070_ sky130_fd_sc_hd__inv_2
X_3109_ _1010_ _1021_ _1025_ VGND VGND VPWR VPWR _1030_ sky130_fd_sc_hd__nand3_1
XFILLER_55_255 VPWR VGND VPWR VGND sky130_ef_sc_hd__decap_12
XFILLER_11_303 VGND VGND VPWR VPWR sky130_fd_sc_hd__decap_6
XFILLER_51_494 VGND VGND VPWR VPWR sky130_fd_sc_hd__decap_8
XPHY_EDGE_ROW_83_Left_177 VGND VGND VPWR VPWR sky130_fd_sc_hd__decap_3
XTAP_TAPCELL_ROW_21_397 VGND VPWR sky130_fd_sc_hd__tapvpwrvgnd_1
XFILLER_2_3 VPWR VGND VPWR VGND sky130_ef_sc_hd__decap_12
XFILLER_93_328 VGND VGND VPWR VPWR sky130_fd_sc_hd__decap_4
XPHY_EDGE_ROW_92_Left_186 VGND VGND VPWR VPWR sky130_fd_sc_hd__decap_3
XFILLER_74_531 VGND VGND VPWR VPWR sky130_fd_sc_hd__fill_1
XFILLER_74_553 VGND VGND VPWR VPWR sky130_fd_sc_hd__fill_1
XTAP_TAPCELL_ROW_57_740 VGND VPWR sky130_fd_sc_hd__tapvpwrvgnd_1
XTAP_TAPCELL_ROW_29_475 VGND VPWR sky130_fd_sc_hd__tapvpwrvgnd_1
XPHY_EDGE_ROW_1_Left_95 VGND VGND VPWR VPWR sky130_fd_sc_hd__decap_3
XFILLER_14_141 VPWR VGND VPWR VGND sky130_ef_sc_hd__decap_12
XTAP_TAPCELL_ROW_12_320 VGND VPWR sky130_fd_sc_hd__tapvpwrvgnd_1
Xinput13 D_a_10[4] VGND VGND VPWR VPWR net13 sky130_fd_sc_hd__clkbuf_1
Xinput24 D_b_00[7] VGND VGND VPWR VPWR net24 sky130_fd_sc_hd__buf_1
Xinput35 num_matrix[0] VGND VGND VPWR VPWR net35 sky130_fd_sc_hd__clkbuf_1
X_3460_ _1329_ _1334_ VGND VGND VPWR VPWR _1374_ sky130_fd_sc_hd__xnor2_1
X_3391_ _1290_ _1309_ _1308_ _1304_ VGND VGND VPWR VPWR _1312_ sky130_fd_sc_hd__a211o_1
X_2411_ net273 net270 net219 net217 VGND VGND VPWR VPWR _2110_ sky130_fd_sc_hd__and4_1
X_2342_ net264 net220 net262 net254 VGND VGND VPWR VPWR _2041_ sky130_fd_sc_hd__a22oi_2
X_2273_ _1965_ _1970_ VGND VGND VPWR VPWR _1972_ sky130_fd_sc_hd__xnor2_1
X_4012_ net34 net33 net71 VGND VGND VPWR VPWR _1861_ sky130_fd_sc_hd__a21o_1
XFILLER_84_339 VGND VGND VPWR VPWR sky130_fd_sc_hd__decap_6
XFILLER_77_380 VPWR VGND VPWR VGND sky130_ef_sc_hd__decap_12
XFILLER_37_222 VGND VGND VPWR VPWR sky130_fd_sc_hd__fill_2
XFILLER_37_233 VGND VGND VPWR VPWR sky130_fd_sc_hd__fill_2
XFILLER_92_350 VPWR VGND VPWR VGND sky130_ef_sc_hd__decap_12
XFILLER_80_545 VGND VGND VPWR VPWR sky130_fd_sc_hd__decap_8
XTAP_TAPCELL_ROW_63_798 VGND VPWR sky130_fd_sc_hd__tapvpwrvgnd_1
XFILLER_32_29 VPWR VGND VPWR VGND sky130_ef_sc_hd__decap_12
XFILLER_33_494 VGND VGND VPWR VPWR sky130_fd_sc_hd__decap_8
XFILLER_20_133 VGND VGND VPWR VPWR sky130_fd_sc_hd__decap_6
XFILLER_20_166 VPWR VGND VPWR VGND sky130_ef_sc_hd__decap_12
X_3727_ net189 net195 VGND VGND VPWR VPWR _1616_ sky130_fd_sc_hd__nand2_1
X_3658_ net185 net194 _1472_ VGND VGND VPWR VPWR _1547_ sky130_fd_sc_hd__and3_1
X_3589_ _1476_ _1477_ VGND VGND VPWR VPWR _1478_ sky130_fd_sc_hd__nand2_1
X_2609_ _0501_ _0516_ VGND VGND VPWR VPWR _0583_ sky130_fd_sc_hd__xnor2_1
XFILLER_87_111 VGND VGND VPWR VPWR sky130_fd_sc_hd__fill_1
XFILLER_0_505 VPWR VGND VPWR VGND sky130_ef_sc_hd__decap_12
Xclkbuf_2_2__f_clk clknet_0_clk VGND VGND VPWR VPWR clknet_2_2__leaf_clk sky130_fd_sc_hd__clkbuf_16
XFILLER_73_14 VGND VGND VPWR VPWR sky130_fd_sc_hd__fill_2
XTAP_TAPCELL_ROW_54_710 VGND VPWR sky130_fd_sc_hd__tapvpwrvgnd_1
XFILLER_73_69 VPWR VGND VPWR VGND sky130_ef_sc_hd__decap_12
XTAP_TAPCELL_ROW_26_445 VGND VPWR sky130_fd_sc_hd__tapvpwrvgnd_1
XFILLER_24_461 VGND VGND VPWR VPWR sky130_fd_sc_hd__fill_1
XFILLER_22_40 VGND VGND VPWR VPWR sky130_fd_sc_hd__fill_1
XFILLER_22_95 VGND VGND VPWR VPWR sky130_fd_sc_hd__fill_1
XFILLER_78_166 VPWR VGND VPWR VGND sky130_ef_sc_hd__decap_12
XFILLER_93_125 VPWR VGND VPWR VGND sky130_ef_sc_hd__decap_12
XFILLER_19_222 VGND VGND VPWR VPWR sky130_fd_sc_hd__fill_2
Xfanout190 systolic_unit_0.U_01.out_b\[0\] VGND VGND VPWR VPWR net190 sky130_fd_sc_hd__clkbuf_2
XFILLER_93_169 VPWR VGND VPWR VGND sky130_ef_sc_hd__decap_12
XFILLER_19_277 VGND VGND VPWR VPWR sky130_fd_sc_hd__decap_3
XFILLER_62_545 VGND VGND VPWR VPWR sky130_fd_sc_hd__fill_1
XFILLER_15_461 VGND VGND VPWR VPWR sky130_fd_sc_hd__decap_8
X_2960_ net131 net177 _0912_ VGND VGND VPWR VPWR _0913_ sky130_fd_sc_hd__nand3_2
X_2891_ _0832_ _0833_ VGND VGND VPWR VPWR _0844_ sky130_fd_sc_hd__xnor2_1
XFILLER_15_494 VGND VGND VPWR VPWR sky130_fd_sc_hd__decap_8
XFILLER_30_453 VPWR VGND VPWR VGND sky130_ef_sc_hd__decap_12
XTAP_TAPCELL_ROW_60_768 VGND VPWR sky130_fd_sc_hd__tapvpwrvgnd_1
XFILLER_8_53 VPWR VGND VPWR VGND sky130_ef_sc_hd__decap_12
X_4492_ clknet_leaf_31_clk net315 _0216_ VGND VGND VPWR VPWR systolic_unit_0.out_acc_0_r1\[7\]
+ sky130_fd_sc_hd__dfrtp_1
X_3512_ net295 net76 net83 net390 _1411_ VGND VGND VPWR VPWR _0299_ sky130_fd_sc_hd__a221o_1
X_3443_ net133 _1360_ VGND VGND VPWR VPWR _1361_ sky130_fd_sc_hd__nand2_1
XFILLER_69_144 VGND VGND VPWR VPWR sky130_fd_sc_hd__decap_6
XFILLER_69_111 VGND VGND VPWR VPWR sky130_fd_sc_hd__fill_1
X_3374_ _1266_ _1291_ _1290_ _1287_ VGND VGND VPWR VPWR _1295_ sky130_fd_sc_hd__o211ai_1
X_2325_ _2021_ _2023_ VGND VGND VPWR VPWR _2024_ sky130_fd_sc_hd__and2b_1
XTAP_TAPCELL_ROW_68_846 VGND VPWR sky130_fd_sc_hd__tapvpwrvgnd_1
X_2256_ systolic_unit_0.U_00.acc_1\[9\] systolic_unit_0.U_00.acc_0\[9\] net208 VGND
+ VGND VPWR VPWR _1955_ sky130_fd_sc_hd__mux2_1
XFILLER_57_328 VGND VGND VPWR VPWR sky130_fd_sc_hd__fill_1
XFILLER_72_309 VPWR VGND VPWR VGND sky130_ef_sc_hd__decap_12
X_2187_ net339 _1893_ net92 VGND VGND VPWR VPWR _0392_ sky130_fd_sc_hd__mux2_1
XFILLER_25_225 VGND VGND VPWR VPWR sky130_fd_sc_hd__fill_2
XTAP_TAPCELL_ROW_31_492 VGND VPWR sky130_fd_sc_hd__tapvpwrvgnd_1
XFILLER_0_335 VGND VGND VPWR VPWR sky130_fd_sc_hd__fill_1
XFILLER_88_475 VGND VGND VPWR VPWR sky130_fd_sc_hd__fill_1
XFILLER_29_520 VPWR VGND VPWR VGND sky130_ef_sc_hd__decap_12
XTAP_TAPCELL_ROW_89_1048 VGND VPWR sky130_fd_sc_hd__tapvpwrvgnd_1
XFILLER_75_147 VGND VGND VPWR VPWR sky130_fd_sc_hd__decap_6
XTAP_TAPCELL_ROW_39_570 VGND VPWR sky130_fd_sc_hd__tapvpwrvgnd_1
XFILLER_90_139 VGND VGND VPWR VPWR sky130_fd_sc_hd__fill_1
XFILLER_31_217 VGND VGND VPWR VPWR sky130_fd_sc_hd__decap_6
XFILLER_12_475 VGND VGND VPWR VPWR sky130_fd_sc_hd__fill_1
XFILLER_8_457 VPWR VGND VPWR VGND sky130_ef_sc_hd__decap_12
X_3090_ _0995_ _0999_ VGND VGND VPWR VPWR _1011_ sky130_fd_sc_hd__xnor2_1
XFILLER_66_169 VPWR VGND VPWR VGND sky130_ef_sc_hd__decap_12
XTAP_TAPCELL_ROW_65_816 VGND VPWR sky130_fd_sc_hd__tapvpwrvgnd_1
X_3992_ net322 _1847_ VGND VGND VPWR VPWR _0262_ sky130_fd_sc_hd__and2_1
XTAP_TAPCELL_ROW_73_893 VGND VPWR sky130_fd_sc_hd__tapvpwrvgnd_1
X_2943_ net177 net129 VGND VGND VPWR VPWR _0896_ sky130_fd_sc_hd__nand2_1
X_2874_ net130 net169 _0825_ VGND VGND VPWR VPWR _0827_ sky130_fd_sc_hd__and3_1
XFILLER_89_217 VGND VGND VPWR VPWR sky130_fd_sc_hd__decap_6
X_4475_ clknet_leaf_32_clk net312 _0199_ VGND VGND VPWR VPWR systolic_unit_0.out_acc_1_r1\[6\]
+ sky130_fd_sc_hd__dfrtp_1
X_3426_ _0991_ _0992_ _0989_ VGND VGND VPWR VPWR _1347_ sky130_fd_sc_hd__a21oi_1
X_3357_ _1243_ _1261_ _1274_ VGND VGND VPWR VPWR _1278_ sky130_fd_sc_hd__o21bai_1
X_2308_ _2004_ _2005_ _2003_ VGND VGND VPWR VPWR _2007_ sky130_fd_sc_hd__a21bo_1
X_3288_ systolic_unit_0.U_00.out_b\[2\] net109 VGND VGND VPWR VPWR _1209_ sky130_fd_sc_hd__and2_1
XFILLER_57_147 VGND VGND VPWR VPWR sky130_fd_sc_hd__fill_1
X_2239_ _1935_ _1936_ _1934_ VGND VGND VPWR VPWR _1938_ sky130_fd_sc_hd__a21boi_1
XFILLER_26_501 VGND VGND VPWR VPWR sky130_fd_sc_hd__decap_4
XFILLER_26_523 VGND VGND VPWR VPWR sky130_fd_sc_hd__decap_8
XFILLER_26_545 VGND VGND VPWR VPWR sky130_fd_sc_hd__decap_8
XFILLER_38_394 VGND VGND VPWR VPWR sky130_fd_sc_hd__fill_2
XFILLER_54_27 VGND VGND VPWR VPWR sky130_fd_sc_hd__fill_1
XTAP_TAPCELL_ROW_36_540 VGND VPWR sky130_fd_sc_hd__tapvpwrvgnd_1
XTAP_TAPCELL_ROW_0_198 VGND VPWR sky130_fd_sc_hd__tapvpwrvgnd_1
XFILLER_53_386 VGND VGND VPWR VPWR sky130_fd_sc_hd__decap_6
XFILLER_70_26 VGND VGND VPWR VPWR sky130_fd_sc_hd__fill_2
XFILLER_5_405 VPWR VGND VPWR VGND sky130_ef_sc_hd__decap_12
XFILLER_5_449 VPWR VGND VPWR VGND sky130_ef_sc_hd__decap_12
XFILLER_79_57 VPWR VGND VPWR VGND sky130_ef_sc_hd__decap_12
XTAP_TAPCELL_ROW_8_276 VGND VPWR sky130_fd_sc_hd__tapvpwrvgnd_1
XFILLER_0_165 VGND VGND VPWR VPWR sky130_fd_sc_hd__decap_3
XFILLER_76_445 VPWR VGND VPWR VGND sky130_ef_sc_hd__decap_12
XFILLER_36_309 VGND VGND VPWR VPWR sky130_fd_sc_hd__decap_4
XFILLER_48_158 VGND VGND VPWR VPWR sky130_fd_sc_hd__decap_4
XFILLER_91_437 VGND VGND VPWR VPWR sky130_fd_sc_hd__decap_8
XFILLER_48_169 VGND VGND VPWR VPWR sky130_fd_sc_hd__fill_2
XFILLER_29_383 VGND VGND VPWR VPWR sky130_fd_sc_hd__fill_1
XTAP_TAPCELL_ROW_70_863 VGND VPWR sky130_fd_sc_hd__tapvpwrvgnd_1
XTAP_TAPCELL_ROW_42_598 VGND VPWR sky130_fd_sc_hd__tapvpwrvgnd_1
XFILLER_12_294 VPWR VGND VPWR VGND sky130_ef_sc_hd__decap_12
XFILLER_60_70 VPWR VGND VPWR VGND sky130_ef_sc_hd__decap_12
X_2590_ _0537_ _0570_ _0568_ VGND VGND VPWR VPWR _0571_ sky130_fd_sc_hd__a21oi_1
X_4260_ net237 VGND VGND VPWR VPWR _0241_ sky130_fd_sc_hd__inv_2
XFILLER_86_209 VPWR VGND VPWR VGND sky130_ef_sc_hd__decap_12
X_3211_ net158 net109 net156 net107 VGND VGND VPWR VPWR _1132_ sky130_fd_sc_hd__and4_1
X_4191_ net233 VGND VGND VPWR VPWR _0172_ sky130_fd_sc_hd__inv_2
XFILLER_67_401 VGND VGND VPWR VPWR sky130_fd_sc_hd__fill_1
XFILLER_79_261 VPWR VGND VPWR VGND sky130_ef_sc_hd__decap_12
X_3142_ _1041_ _1045_ _1044_ VGND VGND VPWR VPWR _1063_ sky130_fd_sc_hd__a21oi_1
XTAP_TAPCELL_ROW_78_941 VGND VPWR sky130_fd_sc_hd__tapvpwrvgnd_1
XFILLER_67_445 VGND VGND VPWR VPWR sky130_fd_sc_hd__decap_3
X_3073_ _0982_ _0987_ VGND VGND VPWR VPWR _0994_ sky130_fd_sc_hd__xnor2_1
XFILLER_82_448 VGND VGND VPWR VPWR sky130_fd_sc_hd__fill_2
XFILLER_35_364 VGND VGND VPWR VPWR sky130_fd_sc_hd__fill_1
XFILLER_62_150 VGND VGND VPWR VPWR sky130_fd_sc_hd__decap_4
X_3975_ net97 _1808_ net81 net392 _1839_ VGND VGND VPWR VPWR _0252_ sky130_fd_sc_hd__a221o_1
X_2926_ net175 net128 _0878_ VGND VGND VPWR VPWR _0879_ sky130_fd_sc_hd__and3_1
XFILLER_50_378 VGND VGND VPWR VPWR sky130_fd_sc_hd__fill_2
X_2857_ _0808_ _0809_ VGND VGND VPWR VPWR _0810_ sky130_fd_sc_hd__nand2_1
XFILLER_40_29 VGND VGND VPWR VPWR sky130_fd_sc_hd__decap_4
X_2788_ _0715_ _0716_ VGND VGND VPWR VPWR _0741_ sky130_fd_sc_hd__xnor2_1
XFILLER_2_419 VGND VGND VPWR VPWR sky130_fd_sc_hd__fill_1
X_4458_ clknet_leaf_0_clk _0407_ _0182_ VGND VGND VPWR VPWR net67 sky130_fd_sc_hd__dfrtp_1
X_3409_ _1191_ _1193_ _1185_ _1187_ VGND VGND VPWR VPWR _1330_ sky130_fd_sc_hd__o211ai_1
XTAP_TAPCELL_ROW_5_246 VGND VPWR sky130_fd_sc_hd__tapvpwrvgnd_1
X_4389_ clknet_leaf_1_clk _0362_ _0113_ VGND VGND VPWR VPWR systolic_unit_0.U_00.acc_1\[9\]
+ sky130_fd_sc_hd__dfrtp_1
XFILLER_58_401 VGND VGND VPWR VPWR sky130_fd_sc_hd__decap_4
XTAP_TAPCELL_ROW_86_1018 VGND VPWR sky130_fd_sc_hd__tapvpwrvgnd_1
XFILLER_85_297 VGND VGND VPWR VPWR sky130_fd_sc_hd__fill_1
XTAP_TAPCELL_ROW_84_999 VGND VPWR sky130_fd_sc_hd__tapvpwrvgnd_1
XFILLER_26_353 VGND VGND VPWR VPWR sky130_fd_sc_hd__fill_2
XFILLER_81_69 VPWR VGND VPWR VGND sky130_ef_sc_hd__decap_12
XFILLER_81_47 VGND VGND VPWR VPWR sky130_fd_sc_hd__fill_1
XFILLER_14_41 VGND VGND VPWR VPWR sky130_fd_sc_hd__decap_4
XFILLER_41_378 VPWR VGND VPWR VGND sky130_ef_sc_hd__decap_12
XFILLER_14_85 VGND VGND VPWR VPWR sky130_fd_sc_hd__fill_1
XFILLER_5_279 VGND VGND VPWR VPWR sky130_fd_sc_hd__fill_1
XFILLER_68_209 VPWR VGND VPWR VGND sky130_ef_sc_hd__decap_12
XFILLER_1_441 VGND VGND VPWR VPWR sky130_fd_sc_hd__decap_6
XFILLER_1_485 VPWR VGND VPWR VGND sky130_ef_sc_hd__decap_12
XFILLER_76_253 VGND VGND VPWR VPWR sky130_fd_sc_hd__decap_4
XTAP_TAPCELL_ROW_75_911 VGND VPWR sky130_fd_sc_hd__tapvpwrvgnd_1
XFILLER_91_223 VGND VGND VPWR VPWR sky130_fd_sc_hd__fill_1
XTAP_TAPCELL_ROW_47_646 VGND VPWR sky130_fd_sc_hd__tapvpwrvgnd_1
XFILLER_91_278 VGND VGND VPWR VPWR sky130_fd_sc_hd__fill_2
XFILLER_44_161 VGND VGND VPWR VPWR sky130_fd_sc_hd__decap_6
XFILLER_20_518 VPWR VGND VPWR VGND sky130_ef_sc_hd__decap_12
X_3760_ _1646_ _1648_ VGND VGND VPWR VPWR _1649_ sky130_fd_sc_hd__and2b_1
X_2711_ _0660_ _0661_ VGND VGND VPWR VPWR _0664_ sky130_fd_sc_hd__xor2_1
XFILLER_9_541 VPWR VGND VPWR VGND sky130_ef_sc_hd__decap_12
X_3691_ net189 net193 _1578_ VGND VGND VPWR VPWR _1580_ sky130_fd_sc_hd__and3_1
X_2642_ net119 net165 net117 systolic_unit_0.U_00.out_a\[6\] VGND VGND VPWR VPWR _0595_
+ sky130_fd_sc_hd__a22o_1
X_2573_ _1915_ _1916_ _1921_ _1914_ _1912_ VGND VGND VPWR VPWR _0558_ sky130_fd_sc_hd__o32a_1
XTAP_TAPCELL_ROW_10_292 VGND VPWR sky130_fd_sc_hd__tapvpwrvgnd_1
X_4312_ clknet_leaf_29_clk _0293_ _0036_ VGND VGND VPWR VPWR systolic_unit_0.U_10.acc_1\[4\]
+ sky130_fd_sc_hd__dfrtp_1
X_4243_ net229 VGND VGND VPWR VPWR _0224_ sky130_fd_sc_hd__inv_2
XFILLER_87_529 VPWR VGND VPWR VGND sky130_ef_sc_hd__decap_12
X_4174_ net250 VGND VGND VPWR VPWR _0155_ sky130_fd_sc_hd__inv_2
XFILLER_67_220 VGND VGND VPWR VPWR sky130_fd_sc_hd__decap_4
XTAP_TAPCELL_ROW_2_216 VGND VPWR sky130_fd_sc_hd__tapvpwrvgnd_1
X_3125_ _1041_ _1044_ _1045_ VGND VGND VPWR VPWR _1046_ sky130_fd_sc_hd__and3_1
XFILLER_55_404 VPWR VGND VPWR VGND sky130_ef_sc_hd__decap_12
X_3056_ systolic_unit_0.U_10.acc_0\[15\] systolic_unit_0.U_00.acc_0\[15\] net207 VGND
+ VGND VPWR VPWR _0977_ sky130_fd_sc_hd__mux2_1
XFILLER_70_407 VGND VGND VPWR VPWR sky130_fd_sc_hd__fill_1
XTAP_TAPCELL_ROW_18_370 VGND VPWR sky130_fd_sc_hd__tapvpwrvgnd_1
XTAP_TAPCELL_ROW_81_969 VGND VPWR sky130_fd_sc_hd__tapvpwrvgnd_1
XFILLER_11_529 VPWR VGND VPWR VGND sky130_ef_sc_hd__decap_12
X_3958_ systolic_unit_0.U_01.drain_1 net147 VGND VGND VPWR VPWR _1831_ sky130_fd_sc_hd__nand2_1
X_2909_ _0796_ _0861_ VGND VGND VPWR VPWR _0862_ sky130_fd_sc_hd__nor2_1
X_3889_ _1432_ _1439_ _1436_ VGND VGND VPWR VPWR _1778_ sky130_fd_sc_hd__a21oi_1
XTAP_TAPCELL_ROW_92_1077 VGND VPWR sky130_fd_sc_hd__tapvpwrvgnd_1
XFILLER_78_507 VPWR VGND VPWR VGND sky130_ef_sc_hd__decap_12
XFILLER_58_220 VGND VGND VPWR VPWR sky130_fd_sc_hd__decap_6
XFILLER_58_242 VGND VGND VPWR VPWR sky130_fd_sc_hd__decap_6
XFILLER_73_223 VGND VGND VPWR VPWR sky130_fd_sc_hd__fill_1
XFILLER_18_139 VGND VGND VPWR VPWR sky130_fd_sc_hd__fill_1
XFILLER_14_312 VGND VGND VPWR VPWR sky130_fd_sc_hd__fill_1
XTAP_TAPCELL_ROW_44_616 VGND VPWR sky130_fd_sc_hd__tapvpwrvgnd_1
XFILLER_25_51 VGND VGND VPWR VPWR sky130_fd_sc_hd__decap_4
XFILLER_14_389 VPWR VGND VPWR VGND sky130_ef_sc_hd__decap_12
XTAP_TAPCELL_ROW_52_693 VGND VPWR sky130_fd_sc_hd__tapvpwrvgnd_1
XFILLER_6_533 VPWR VGND VPWR VGND sky130_ef_sc_hd__decap_12
XFILLER_69_529 VPWR VGND VPWR VGND sky130_ef_sc_hd__decap_12
XFILLER_2_77 VGND VGND VPWR VPWR sky130_fd_sc_hd__decap_6
XFILLER_37_437 VGND VGND VPWR VPWR sky130_fd_sc_hd__decap_8
XFILLER_64_245 VGND VGND VPWR VPWR sky130_fd_sc_hd__decap_6
XTAP_TAPCELL_ROW_15_340 VGND VPWR sky130_fd_sc_hd__tapvpwrvgnd_1
XFILLER_32_153 VPWR VGND VPWR VGND sky130_ef_sc_hd__decap_12
X_3812_ _1695_ _1700_ VGND VGND VPWR VPWR _1701_ sky130_fd_sc_hd__or2_1
XFILLER_60_462 VGND VGND VPWR VPWR sky130_fd_sc_hd__decap_4
XFILLER_20_326 VGND VGND VPWR VPWR sky130_fd_sc_hd__fill_1
X_3743_ net200 net182 _1624_ _1623_ VGND VGND VPWR VPWR _1632_ sky130_fd_sc_hd__a31o_1
XFILLER_9_393 VPWR VGND VPWR VGND sky130_ef_sc_hd__decap_12
X_3674_ _1547_ _1551_ _1562_ VGND VGND VPWR VPWR _1563_ sky130_fd_sc_hd__o21a_1
X_2625_ net99 _0567_ net79 net378 VGND VGND VPWR VPWR _0365_ sky130_fd_sc_hd__a22o_1
X_2556_ _1974_ _1977_ _0540_ VGND VGND VPWR VPWR _0541_ sky130_fd_sc_hd__a21o_1
X_2487_ _0455_ _0471_ VGND VGND VPWR VPWR _0472_ sky130_fd_sc_hd__nor2_1
XFILLER_87_348 VPWR VGND VPWR VGND sky130_ef_sc_hd__decap_12
XFILLER_87_337 VGND VGND VPWR VPWR sky130_fd_sc_hd__decap_4
X_4226_ net230 VGND VGND VPWR VPWR _0207_ sky130_fd_sc_hd__inv_2
X_4157_ net232 VGND VGND VPWR VPWR _0138_ sky130_fd_sc_hd__inv_2
X_3108_ _1027_ _1028_ VGND VGND VPWR VPWR _1029_ sky130_fd_sc_hd__nand2b_1
X_4088_ net238 VGND VGND VPWR VPWR _0069_ sky130_fd_sc_hd__inv_2
XFILLER_55_267 VPWR VGND VPWR VGND sky130_ef_sc_hd__decap_12
X_3039_ systolic_unit_0.U_01.drain_1 net94 VGND VGND VPWR VPWR _0976_ sky130_fd_sc_hd__nor2_1
XFILLER_23_142 VGND VGND VPWR VPWR sky130_fd_sc_hd__decap_8
XFILLER_23_164 VGND VGND VPWR VPWR sky130_fd_sc_hd__decap_4
XFILLER_3_503 VGND VGND VPWR VPWR sky130_fd_sc_hd__fill_1
XTAP_TAPCELL_ROW_21_398 VGND VPWR sky130_fd_sc_hd__tapvpwrvgnd_1
XFILLER_87_57 VPWR VGND VPWR VGND sky130_ef_sc_hd__decap_12
XFILLER_93_307 VGND VGND VPWR VPWR sky130_fd_sc_hd__fill_1
XFILLER_19_437 VGND VGND VPWR VPWR sky130_fd_sc_hd__decap_8
XFILLER_19_459 VGND VGND VPWR VPWR sky130_fd_sc_hd__fill_1
XTAP_TAPCELL_ROW_57_741 VGND VPWR sky130_fd_sc_hd__tapvpwrvgnd_1
XTAP_TAPCELL_ROW_29_476 VGND VPWR sky130_fd_sc_hd__tapvpwrvgnd_1
XFILLER_14_153 VGND VGND VPWR VPWR sky130_fd_sc_hd__decap_6
XFILLER_42_451 VGND VGND VPWR VPWR sky130_fd_sc_hd__decap_3
XFILLER_14_197 VGND VGND VPWR VPWR sky130_fd_sc_hd__decap_4
XFILLER_42_484 VPWR VGND VPWR VGND sky130_ef_sc_hd__decap_12
XFILLER_52_71 VPWR VGND VPWR VGND sky130_ef_sc_hd__decap_12
Xinput25 D_b_01[0] VGND VGND VPWR VPWR net25 sky130_fd_sc_hd__clkbuf_1
Xinput14 D_a_10[5] VGND VGND VPWR VPWR net14 sky130_fd_sc_hd__clkbuf_1
Xinput36 num_matrix[1] VGND VGND VPWR VPWR net36 sky130_fd_sc_hd__clkbuf_1
XFILLER_6_363 VGND VGND VPWR VPWR sky130_fd_sc_hd__fill_1
X_2410_ net274 net261 _2108_ VGND VGND VPWR VPWR _2109_ sky130_fd_sc_hd__nand3_1
X_3390_ _1304_ _1308_ _1309_ _1290_ VGND VGND VPWR VPWR _1311_ sky130_fd_sc_hd__o211ai_1
X_2341_ net268 net219 VGND VGND VPWR VPWR _2040_ sky130_fd_sc_hd__nand2_1
X_2272_ _1965_ _1970_ VGND VGND VPWR VPWR _1971_ sky130_fd_sc_hd__and2b_1
XFILLER_69_337 VGND VGND VPWR VPWR sky130_fd_sc_hd__fill_1
X_4011_ _1855_ _1856_ _1857_ _1858_ net72 VGND VGND VPWR VPWR _1860_ sky130_fd_sc_hd__a221o_1
XFILLER_28_3 VGND VGND VPWR VPWR sky130_fd_sc_hd__decap_6
XFILLER_25_407 VGND VGND VPWR VPWR sky130_fd_sc_hd__fill_2
XFILLER_92_362 VGND VGND VPWR VPWR sky130_fd_sc_hd__fill_2
XFILLER_37_267 VGND VGND VPWR VPWR sky130_fd_sc_hd__decap_6
XFILLER_20_101 VPWR VGND VPWR VGND sky130_ef_sc_hd__decap_12
XTAP_TAPCELL_ROW_63_799 VGND VPWR sky130_fd_sc_hd__tapvpwrvgnd_1
XFILLER_20_178 VPWR VGND VPWR VGND sky130_ef_sc_hd__decap_12
X_3726_ systolic_unit_0.U_11.acc_1\[5\] systolic_unit_0.U_11.acc_0\[5\] net145 VGND
+ VGND VPWR VPWR _1615_ sky130_fd_sc_hd__mux2_1
X_3657_ net197 systolic_unit_0.U_01.out_b\[4\] VGND VGND VPWR VPWR _1546_ sky130_fd_sc_hd__and2_1
X_3588_ _1470_ _1475_ VGND VGND VPWR VPWR _1477_ sky130_fd_sc_hd__or2_1
X_2608_ systolic_unit_0.U_00.acc_0\[5\] net89 _0582_ net211 VGND VGND VPWR VPWR _0374_
+ sky130_fd_sc_hd__a22o_1
XFILLER_0_517 VPWR VGND VPWR VGND sky130_ef_sc_hd__decap_12
X_2539_ _0467_ _0523_ VGND VGND VPWR VPWR _0524_ sky130_fd_sc_hd__nand2_1
XFILLER_87_167 VGND VGND VPWR VPWR sky130_fd_sc_hd__fill_1
X_4209_ net223 VGND VGND VPWR VPWR _0190_ sky130_fd_sc_hd__inv_2
XFILLER_71_502 VGND VGND VPWR VPWR sky130_fd_sc_hd__fill_2
XTAP_TAPCELL_ROW_54_711 VGND VPWR sky130_fd_sc_hd__tapvpwrvgnd_1
XTAP_TAPCELL_ROW_26_446 VGND VPWR sky130_fd_sc_hd__tapvpwrvgnd_1
XFILLER_51_281 VPWR VGND VPWR VGND sky130_ef_sc_hd__decap_12
XFILLER_78_178 VPWR VGND VPWR VGND sky130_ef_sc_hd__decap_12
XFILLER_93_137 VGND VGND VPWR VPWR sky130_fd_sc_hd__decap_3
Xfanout191 systolic_unit_0.U_10.out_a\[7\] VGND VGND VPWR VPWR net191 sky130_fd_sc_hd__buf_2
Xfanout180 systolic_unit_0.U_01.out_b\[6\] VGND VGND VPWR VPWR net180 sky130_fd_sc_hd__buf_2
XFILLER_59_370 VGND VGND VPWR VPWR sky130_fd_sc_hd__decap_3
XFILLER_59_381 VGND VGND VPWR VPWR sky130_fd_sc_hd__decap_8
XFILLER_19_289 VGND VGND VPWR VPWR sky130_fd_sc_hd__fill_2
XFILLER_62_502 VPWR VGND VPWR VGND sky130_ef_sc_hd__decap_12
X_2890_ _0837_ _0838_ VGND VGND VPWR VPWR _0843_ sky130_fd_sc_hd__xor2_1
XFILLER_30_421 VPWR VGND VPWR VGND sky130_ef_sc_hd__decap_12
XFILLER_30_465 VGND VGND VPWR VPWR sky130_fd_sc_hd__decap_3
XTAP_TAPCELL_ROW_60_769 VGND VPWR sky130_fd_sc_hd__tapvpwrvgnd_1
XFILLER_8_65 VPWR VGND VPWR VGND sky130_ef_sc_hd__decap_12
XFILLER_30_498 VGND VGND VPWR VPWR sky130_fd_sc_hd__fill_1
X_4491_ clknet_leaf_0_clk net317 _0215_ VGND VGND VPWR VPWR systolic_unit_0.out_acc_0_r1\[6\]
+ sky130_fd_sc_hd__dfrtp_1
X_3511_ net132 _1368_ VGND VGND VPWR VPWR _1411_ sky130_fd_sc_hd__nor2_1
X_3442_ _1340_ _1341_ VGND VGND VPWR VPWR _1360_ sky130_fd_sc_hd__xnor2_1
XFILLER_69_101 VGND VGND VPWR VPWR sky130_fd_sc_hd__decap_3
X_3373_ _1207_ _1268_ _1293_ VGND VGND VPWR VPWR _1294_ sky130_fd_sc_hd__o21a_1
X_2324_ _2009_ _2022_ VGND VGND VPWR VPWR _2023_ sky130_fd_sc_hd__xor2_1
XFILLER_69_167 VGND VGND VPWR VPWR sky130_fd_sc_hd__fill_1
X_2255_ _1952_ _1953_ VGND VGND VPWR VPWR _1954_ sky130_fd_sc_hd__nand2_1
XFILLER_69_178 VGND VGND VPWR VPWR sky130_fd_sc_hd__fill_1
XTAP_TAPCELL_ROW_68_847 VGND VPWR sky130_fd_sc_hd__tapvpwrvgnd_1
X_2186_ systolic_unit_0.U_11.acc_0\[7\] systolic_unit_0.U_11.acc_1\[7\] net147 VGND
+ VGND VPWR VPWR _1893_ sky130_fd_sc_hd__mux2_1
XFILLER_65_351 VPWR VGND VPWR VGND sky130_ef_sc_hd__decap_12
XFILLER_21_410 VPWR VGND VPWR VGND sky130_ef_sc_hd__decap_12
XTAP_TAPCELL_ROW_23_416 VGND VPWR sky130_fd_sc_hd__tapvpwrvgnd_1
XFILLER_21_465 VGND VGND VPWR VPWR sky130_fd_sc_hd__fill_2
XTAP_TAPCELL_ROW_31_493 VGND VPWR sky130_fd_sc_hd__tapvpwrvgnd_1
X_3709_ _1585_ _1587_ _1586_ VGND VGND VPWR VPWR _1598_ sky130_fd_sc_hd__o21ba_1
XFILLER_0_314 VGND VGND VPWR VPWR sky130_fd_sc_hd__decap_4
XFILLER_48_307 VGND VGND VPWR VPWR sky130_fd_sc_hd__fill_1
XTAP_TAPCELL_ROW_89_1049 VGND VPWR sky130_fd_sc_hd__tapvpwrvgnd_1
XFILLER_29_532 VPWR VGND VPWR VGND sky130_ef_sc_hd__decap_12
XTAP_TAPCELL_ROW_39_571 VGND VPWR sky130_fd_sc_hd__tapvpwrvgnd_1
XFILLER_83_181 VPWR VGND VPWR VGND sky130_ef_sc_hd__decap_12
XFILLER_12_421 VPWR VGND VPWR VGND sky130_ef_sc_hd__decap_12
XFILLER_8_469 VGND VGND VPWR VPWR sky130_fd_sc_hd__decap_6
XFILLER_79_476 VPWR VGND VPWR VGND sky130_ef_sc_hd__decap_12
XFILLER_39_329 VGND VGND VPWR VPWR sky130_fd_sc_hd__decap_6
XFILLER_66_115 VGND VGND VPWR VPWR sky130_fd_sc_hd__fill_1
XFILLER_47_351 VGND VGND VPWR VPWR sky130_fd_sc_hd__fill_1
XTAP_TAPCELL_ROW_65_817 VGND VPWR sky130_fd_sc_hd__tapvpwrvgnd_1
X_3991_ net100 _1847_ VGND VGND VPWR VPWR _0261_ sky130_fd_sc_hd__and2_1
XTAP_TAPCELL_ROW_73_894 VGND VPWR sky130_fd_sc_hd__tapvpwrvgnd_1
X_2942_ net130 net175 _0894_ VGND VGND VPWR VPWR _0895_ sky130_fd_sc_hd__and3_1
XFILLER_15_281 VPWR VGND VPWR VGND sky130_ef_sc_hd__decap_12
X_2873_ net130 net169 VGND VGND VPWR VPWR _0826_ sky130_fd_sc_hd__nand2_1
XFILLER_30_251 VGND VGND VPWR VPWR sky130_fd_sc_hd__fill_1
X_4474_ clknet_leaf_29_clk net306 _0198_ VGND VGND VPWR VPWR systolic_unit_0.out_acc_1_r1\[5\]
+ sky130_fd_sc_hd__dfrtp_1
X_3425_ _1344_ _1058_ _1028_ _1027_ VGND VGND VPWR VPWR _1346_ sky130_fd_sc_hd__a31o_1
X_3356_ _1270_ _1272_ VGND VGND VPWR VPWR _1277_ sky130_fd_sc_hd__nand2_1
X_2307_ _2003_ _2004_ _2005_ VGND VGND VPWR VPWR _2006_ sky130_fd_sc_hd__nand3_1
X_3287_ net113 net111 net158 net156 VGND VGND VPWR VPWR _1208_ sky130_fd_sc_hd__nand4_1
X_2238_ _1934_ _1935_ _1936_ VGND VGND VPWR VPWR _1937_ sky130_fd_sc_hd__and3_1
X_2169_ net354 _1884_ net93 VGND VGND VPWR VPWR _0401_ sky130_fd_sc_hd__mux2_1
XFILLER_65_181 VGND VGND VPWR VPWR sky130_fd_sc_hd__fill_1
XTAP_TAPCELL_ROW_0_188 VGND VPWR sky130_fd_sc_hd__tapvpwrvgnd_1
XTAP_TAPCELL_ROW_36_541 VGND VPWR sky130_fd_sc_hd__tapvpwrvgnd_1
XTAP_TAPCELL_ROW_0_199 VGND VPWR sky130_fd_sc_hd__tapvpwrvgnd_1
XFILLER_80_195 VGND VGND VPWR VPWR sky130_fd_sc_hd__fill_1
XFILLER_5_417 VPWR VGND VPWR VGND sky130_ef_sc_hd__decap_12
XFILLER_79_69 VPWR VGND VPWR VGND sky130_ef_sc_hd__decap_12
XFILLER_88_251 VGND VGND VPWR VPWR sky130_fd_sc_hd__fill_1
XTAP_TAPCELL_ROW_8_277 VGND VPWR sky130_fd_sc_hd__tapvpwrvgnd_1
XFILLER_76_457 VPWR VGND VPWR VGND sky130_ef_sc_hd__decap_12
XFILLER_17_502 VGND VGND VPWR VPWR sky130_fd_sc_hd__fill_2
XFILLER_91_449 VPWR VGND VPWR VGND sky130_ef_sc_hd__decap_12
XFILLER_44_365 VPWR VGND VPWR VGND sky130_ef_sc_hd__decap_12
XTAP_TAPCELL_ROW_70_864 VGND VPWR sky130_fd_sc_hd__tapvpwrvgnd_1
XFILLER_44_83 VGND VGND VPWR VPWR sky130_fd_sc_hd__fill_1
XTAP_TAPCELL_ROW_42_599 VGND VPWR sky130_fd_sc_hd__tapvpwrvgnd_1
XFILLER_8_266 VPWR VGND VPWR VGND sky130_ef_sc_hd__decap_12
XFILLER_60_82 VGND VGND VPWR VPWR sky130_fd_sc_hd__fill_2
XFILLER_5_55 VGND VGND VPWR VPWR sky130_fd_sc_hd__fill_1
X_3210_ _1108_ _1129_ _1130_ VGND VGND VPWR VPWR _1131_ sky130_fd_sc_hd__nand3_1
X_4190_ net233 VGND VGND VPWR VPWR _0171_ sky130_fd_sc_hd__inv_2
XFILLER_79_273 VGND VGND VPWR VPWR sky130_fd_sc_hd__decap_6
X_3141_ _1052_ _1053_ VGND VGND VPWR VPWR _1062_ sky130_fd_sc_hd__xnor2_1
XTAP_TAPCELL_ROW_78_942 VGND VPWR sky130_fd_sc_hd__tapvpwrvgnd_1
XFILLER_10_3 VPWR VGND VPWR VGND sky130_ef_sc_hd__decap_12
X_3072_ _0991_ _0992_ VGND VGND VPWR VPWR _0993_ sky130_fd_sc_hd__xnor2_1
XFILLER_23_505 VPWR VGND VPWR VGND sky130_ef_sc_hd__decap_12
XFILLER_47_192 VPWR VGND VPWR VGND sky130_ef_sc_hd__decap_12
XTAP_TAPCELL_ROW_33_511 VGND VPWR sky130_fd_sc_hd__tapvpwrvgnd_1
X_3974_ systolic_unit_0.U_01.drain_1 net145 systolic_unit_0.U_11.acc_1\[7\] VGND VGND
+ VPWR VPWR _1839_ sky130_fd_sc_hd__and3b_1
XFILLER_62_195 VGND VGND VPWR VPWR sky130_fd_sc_hd__fill_1
X_2925_ _0874_ _0875_ VGND VGND VPWR VPWR _0878_ sky130_fd_sc_hd__xnor2_1
X_2856_ _0778_ _0806_ VGND VGND VPWR VPWR _0809_ sky130_fd_sc_hd__xnor2_1
X_2787_ _0728_ _0729_ VGND VGND VPWR VPWR _0740_ sky130_fd_sc_hd__xor2_1
X_4457_ clknet_leaf_30_clk _0406_ _0181_ VGND VGND VPWR VPWR net66 sky130_fd_sc_hd__dfrtp_1
X_3408_ _1328_ _1257_ _1259_ VGND VGND VPWR VPWR _1329_ sky130_fd_sc_hd__a21o_1
X_4388_ clknet_leaf_6_clk _0361_ _0112_ VGND VGND VPWR VPWR systolic_unit_0.U_00.acc_1\[8\]
+ sky130_fd_sc_hd__dfrtp_1
X_3339_ _1245_ _1247_ _1246_ VGND VGND VPWR VPWR _1260_ sky130_fd_sc_hd__a21o_1
XTAP_TAPCELL_ROW_5_247 VGND VPWR sky130_fd_sc_hd__tapvpwrvgnd_1
XFILLER_58_457 VGND VGND VPWR VPWR sky130_fd_sc_hd__decap_8
XFILLER_65_38 VGND VGND VPWR VPWR sky130_fd_sc_hd__fill_2
XTAP_TAPCELL_ROW_86_1019 VGND VPWR sky130_fd_sc_hd__tapvpwrvgnd_1
XFILLER_73_449 VGND VGND VPWR VPWR sky130_fd_sc_hd__decap_8
XFILLER_26_321 VGND VGND VPWR VPWR sky130_fd_sc_hd__decap_3
XFILLER_81_15 VPWR VGND VPWR VGND sky130_ef_sc_hd__decap_12
XFILLER_5_203 VPWR VGND VPWR VGND sky130_ef_sc_hd__decap_12
XFILLER_5_225 VPWR VGND VPWR VGND sky130_ef_sc_hd__decap_12
XFILLER_30_41 VGND VGND VPWR VPWR sky130_fd_sc_hd__decap_3
XFILLER_1_497 VGND VGND VPWR VPWR sky130_fd_sc_hd__decap_6
XTAP_TAPCELL_ROW_75_912 VGND VPWR sky130_fd_sc_hd__tapvpwrvgnd_1
XFILLER_64_416 VGND VGND VPWR VPWR sky130_fd_sc_hd__decap_4
XFILLER_29_181 VPWR VGND VPWR VGND sky130_ef_sc_hd__decap_12
XTAP_TAPCELL_ROW_47_647 VGND VPWR sky130_fd_sc_hd__tapvpwrvgnd_1
XFILLER_32_302 VGND VGND VPWR VPWR sky130_fd_sc_hd__decap_3
XFILLER_55_93 VGND VGND VPWR VPWR sky130_fd_sc_hd__fill_1
X_2710_ _0633_ _0658_ _0662_ VGND VGND VPWR VPWR _0663_ sky130_fd_sc_hd__or3_1
XFILLER_71_92 VGND VGND VPWR VPWR sky130_fd_sc_hd__fill_1
XFILLER_9_553 VGND VGND VPWR VPWR sky130_fd_sc_hd__fill_1
X_3690_ net189 net193 VGND VGND VPWR VPWR _1579_ sky130_fd_sc_hd__nand2_1
X_2641_ net165 net117 _0592_ VGND VGND VPWR VPWR _0594_ sky130_fd_sc_hd__nand3_1
X_2572_ _0554_ _0555_ _1946_ VGND VGND VPWR VPWR _0557_ sky130_fd_sc_hd__a21o_1
XTAP_TAPCELL_ROW_10_293 VGND VPWR sky130_fd_sc_hd__tapvpwrvgnd_1
XFILLER_58_3 VPWR VGND VPWR VGND sky130_ef_sc_hd__decap_12
X_4311_ clknet_leaf_26_clk _0292_ _0035_ VGND VGND VPWR VPWR systolic_unit_0.U_10.acc_1\[3\]
+ sky130_fd_sc_hd__dfrtp_1
X_4242_ net230 VGND VGND VPWR VPWR _0223_ sky130_fd_sc_hd__inv_2
X_4173_ net244 VGND VGND VPWR VPWR _0154_ sky130_fd_sc_hd__inv_2
XFILLER_67_243 VGND VGND VPWR VPWR sky130_fd_sc_hd__fill_1
XTAP_TAPCELL_ROW_2_217 VGND VPWR sky130_fd_sc_hd__tapvpwrvgnd_1
X_3124_ _1016_ _1035_ _1040_ VGND VGND VPWR VPWR _1045_ sky130_fd_sc_hd__o21ai_1
XFILLER_55_416 VGND VGND VPWR VPWR sky130_fd_sc_hd__fill_2
XFILLER_55_449 VGND VGND VPWR VPWR sky130_fd_sc_hd__decap_4
X_3055_ net94 _0913_ _0975_ net78 net386 VGND VGND VPWR VPWR _0321_ sky130_fd_sc_hd__a32o_1
XFILLER_82_257 VGND VGND VPWR VPWR sky130_fd_sc_hd__fill_2
XFILLER_63_460 VGND VGND VPWR VPWR sky130_fd_sc_hd__fill_1
XTAP_TAPCELL_ROW_18_371 VGND VPWR sky130_fd_sc_hd__tapvpwrvgnd_1
X_3957_ systolic_unit_0.U_01.drain_1 net144 VGND VGND VPWR VPWR _1830_ sky130_fd_sc_hd__and2_2
X_2908_ _0853_ _0855_ _0854_ VGND VGND VPWR VPWR _0861_ sky130_fd_sc_hd__o21ba_1
X_3888_ _1464_ _1776_ _1462_ VGND VGND VPWR VPWR _1777_ sky130_fd_sc_hd__o21ai_1
X_2839_ _0788_ _0791_ VGND VGND VPWR VPWR _0792_ sky130_fd_sc_hd__xnor2_1
X_4509_ clknet_leaf_8_clk net29 _0233_ VGND VGND VPWR VPWR systolic_unit_0.U_01.in_b\[4\]
+ sky130_fd_sc_hd__dfrtp_1
XTAP_TAPCELL_ROW_92_1078 VGND VPWR sky130_fd_sc_hd__tapvpwrvgnd_1
XFILLER_78_519 VPWR VGND VPWR VGND sky130_ef_sc_hd__decap_12
XFILLER_76_37 VGND VGND VPWR VPWR sky130_fd_sc_hd__decap_8
XFILLER_18_107 VPWR VGND VPWR VGND sky130_ef_sc_hd__decap_12
XFILLER_73_279 VGND VGND VPWR VPWR sky130_fd_sc_hd__fill_1
XTAP_TAPCELL_ROW_44_617 VGND VPWR sky130_fd_sc_hd__tapvpwrvgnd_1
XFILLER_26_184 VGND VGND VPWR VPWR sky130_fd_sc_hd__decap_3
XFILLER_41_121 VGND VGND VPWR VPWR sky130_fd_sc_hd__decap_3
XTAP_TAPCELL_ROW_52_694 VGND VPWR sky130_fd_sc_hd__tapvpwrvgnd_1
XFILLER_6_501 VPWR VGND VPWR VGND sky130_ef_sc_hd__decap_12
XFILLER_6_545 VGND VGND VPWR VPWR sky130_fd_sc_hd__decap_8
XFILLER_77_541 VPWR VGND VPWR VGND sky130_ef_sc_hd__decap_12
XFILLER_92_533 VPWR VGND VPWR VGND sky130_ef_sc_hd__decap_12
Xclkbuf_leaf_29_clk clknet_2_1__leaf_clk VGND VGND VPWR VPWR clknet_leaf_29_clk sky130_fd_sc_hd__clkbuf_8
XTAP_TAPCELL_ROW_15_341 VGND VPWR sky130_fd_sc_hd__tapvpwrvgnd_1
XFILLER_32_165 VPWR VGND VPWR VGND sky130_ef_sc_hd__decap_12
X_3811_ _1653_ _1699_ VGND VGND VPWR VPWR _1700_ sky130_fd_sc_hd__xnor2_1
XFILLER_60_485 VPWR VGND VPWR VGND sky130_ef_sc_hd__decap_12
X_3742_ net202 systolic_unit_0.U_01.out_b\[6\] _1630_ VGND VGND VPWR VPWR _1631_ sky130_fd_sc_hd__and3_1
X_3673_ _1515_ _1561_ VGND VGND VPWR VPWR _1562_ sky130_fd_sc_hd__nor2_1
X_2624_ net99 _0566_ net79 net385 VGND VGND VPWR VPWR _0366_ sky130_fd_sc_hd__a22o_1
X_2555_ _1931_ _1940_ VGND VGND VPWR VPWR _0540_ sky130_fd_sc_hd__xor2_1
X_2486_ _0452_ _0453_ _0454_ _0421_ VGND VGND VPWR VPWR _0471_ sky130_fd_sc_hd__o22a_1
X_4225_ net226 VGND VGND VPWR VPWR _0206_ sky130_fd_sc_hd__inv_2
X_4156_ net224 VGND VGND VPWR VPWR _0137_ sky130_fd_sc_hd__inv_2
X_3107_ _1008_ _1026_ VGND VGND VPWR VPWR _1028_ sky130_fd_sc_hd__nand2_1
XFILLER_46_18 VGND VGND VPWR VPWR sky130_fd_sc_hd__decap_6
X_4087_ net238 VGND VGND VPWR VPWR _0068_ sky130_fd_sc_hd__inv_2
XFILLER_36_460 VPWR VGND VPWR VGND sky130_ef_sc_hd__decap_12
XFILLER_55_279 VGND VGND VPWR VPWR sky130_fd_sc_hd__fill_1
X_3038_ net140 _0913_ _0975_ net84 net388 VGND VGND VPWR VPWR _0337_ sky130_fd_sc_hd__a32o_1
XTAP_TAPCELL_ROW_21_399 VGND VPWR sky130_fd_sc_hd__tapvpwrvgnd_1
XFILLER_87_69 VPWR VGND VPWR VGND sky130_ef_sc_hd__decap_12
XFILLER_19_405 VGND VGND VPWR VPWR sky130_fd_sc_hd__decap_6
XFILLER_74_533 VPWR VGND VPWR VGND sky130_ef_sc_hd__decap_12
XFILLER_19_449 VGND VGND VPWR VPWR sky130_fd_sc_hd__fill_1
XTAP_TAPCELL_ROW_57_742 VGND VPWR sky130_fd_sc_hd__tapvpwrvgnd_1
XTAP_TAPCELL_ROW_29_477 VGND VPWR sky130_fd_sc_hd__tapvpwrvgnd_1
XFILLER_34_419 VGND VGND VPWR VPWR sky130_fd_sc_hd__fill_1
XFILLER_14_165 VGND VGND VPWR VPWR sky130_fd_sc_hd__fill_2
XTAP_TAPCELL_ROW_12_311 VGND VPWR sky130_fd_sc_hd__tapvpwrvgnd_1
XFILLER_42_496 VGND VGND VPWR VPWR sky130_fd_sc_hd__decap_3
XFILLER_52_83 VGND VGND VPWR VPWR sky130_fd_sc_hd__fill_1
Xinput26 D_b_01[1] VGND VGND VPWR VPWR net26 sky130_fd_sc_hd__clkbuf_1
Xinput15 D_a_10[6] VGND VGND VPWR VPWR net15 sky130_fd_sc_hd__clkbuf_1
Xinput37 num_matrix[2] VGND VGND VPWR VPWR net37 sky130_fd_sc_hd__clkbuf_1
X_2340_ net254 net264 net220 net262 VGND VGND VPWR VPWR _2039_ sky130_fd_sc_hd__and4_1
X_2271_ _1967_ _1968_ _1966_ VGND VGND VPWR VPWR _1970_ sky130_fd_sc_hd__a21bo_1
X_4010_ matrix_count\[1\] net36 VGND VGND VPWR VPWR _1859_ sky130_fd_sc_hd__xor2_1
XFILLER_92_341 VGND VGND VPWR VPWR sky130_fd_sc_hd__fill_2
XFILLER_18_482 VPWR VGND VPWR VGND sky130_ef_sc_hd__decap_12
XFILLER_33_463 VGND VGND VPWR VPWR sky130_fd_sc_hd__fill_1
XFILLER_20_113 VPWR VGND VPWR VGND sky130_ef_sc_hd__decap_12
X_3725_ _1581_ _1582_ VGND VGND VPWR VPWR _1614_ sky130_fd_sc_hd__xnor2_2
Xclkbuf_leaf_9_clk clknet_2_2__leaf_clk VGND VGND VPWR VPWR clknet_leaf_9_clk sky130_fd_sc_hd__clkbuf_8
X_3656_ _1538_ _1544_ VGND VGND VPWR VPWR _1545_ sky130_fd_sc_hd__and2_1
X_3587_ _1470_ _1475_ VGND VGND VPWR VPWR _1476_ sky130_fd_sc_hd__nand2_1
X_2607_ _0517_ _0518_ VGND VGND VPWR VPWR _0582_ sky130_fd_sc_hd__xnor2_1
XFILLER_0_529 VGND VGND VPWR VPWR sky130_fd_sc_hd__decap_3
X_2538_ _0488_ _0519_ _0522_ _0468_ VGND VGND VPWR VPWR _0523_ sky130_fd_sc_hd__or4b_4
XFILLER_87_113 VPWR VGND VPWR VGND sky130_ef_sc_hd__decap_12
XFILLER_75_319 VGND VGND VPWR VPWR sky130_fd_sc_hd__decap_8
X_4208_ net232 VGND VGND VPWR VPWR _0189_ sky130_fd_sc_hd__inv_2
X_2469_ net266 net269 net265 net274 VGND VGND VPWR VPWR _0454_ sky130_fd_sc_hd__a22oi_1
XFILLER_56_500 VPWR VGND VPWR VGND sky130_ef_sc_hd__decap_12
X_4139_ net245 VGND VGND VPWR VPWR _0120_ sky130_fd_sc_hd__inv_2
XFILLER_16_408 VPWR VGND VPWR VGND sky130_ef_sc_hd__decap_12
XTAP_TAPCELL_ROW_54_712 VGND VPWR sky130_fd_sc_hd__tapvpwrvgnd_1
XTAP_TAPCELL_ROW_26_447 VGND VPWR sky130_fd_sc_hd__tapvpwrvgnd_1
XFILLER_11_113 VGND VGND VPWR VPWR sky130_fd_sc_hd__fill_2
XFILLER_24_496 VGND VGND VPWR VPWR sky130_fd_sc_hd__fill_1
XFILLER_51_271 VGND VGND VPWR VPWR sky130_fd_sc_hd__decap_8
XFILLER_51_293 VPWR VGND VPWR VGND sky130_ef_sc_hd__decap_12
XFILLER_11_157 VGND VGND VPWR VPWR sky130_fd_sc_hd__decap_8
Xfanout170 systolic_unit_0.U_00.out_a\[4\] VGND VGND VPWR VPWR net170 sky130_fd_sc_hd__dlymetal6s2s_1
Xfanout181 systolic_unit_0.U_01.out_b\[5\] VGND VGND VPWR VPWR net181 sky130_fd_sc_hd__buf_2
Xfanout192 systolic_unit_0.U_10.out_a\[7\] VGND VGND VPWR VPWR net192 sky130_fd_sc_hd__buf_1
XFILLER_59_393 VGND VGND VPWR VPWR sky130_fd_sc_hd__fill_1
XFILLER_62_514 VPWR VGND VPWR VGND sky130_ef_sc_hd__decap_12
XFILLER_15_441 VGND VGND VPWR VPWR sky130_fd_sc_hd__decap_6
XFILLER_30_400 VGND VGND VPWR VPWR sky130_fd_sc_hd__decap_8
XPHY_EDGE_ROW_7_Left_101 VGND VGND VPWR VPWR sky130_fd_sc_hd__decap_3
XFILLER_30_433 VGND VGND VPWR VPWR sky130_fd_sc_hd__decap_6
XFILLER_8_77 VGND VGND VPWR VPWR sky130_fd_sc_hd__decap_6
X_3510_ net96 _1366_ _1410_ VGND VGND VPWR VPWR _0300_ sky130_fd_sc_hd__a21o_1
XFILLER_10_190 VGND VGND VPWR VPWR sky130_fd_sc_hd__decap_6
X_4490_ clknet_leaf_29_clk net296 _0214_ VGND VGND VPWR VPWR systolic_unit_0.out_acc_0_r1\[5\]
+ sky130_fd_sc_hd__dfrtp_1
X_3441_ _1357_ _1359_ net136 VGND VGND VPWR VPWR _0318_ sky130_fd_sc_hd__mux2_1
X_3372_ net114 net160 net158 net115 VGND VGND VPWR VPWR _1293_ sky130_fd_sc_hd__a22o_1
XFILLER_40_3 VGND VGND VPWR VPWR sky130_fd_sc_hd__fill_2
X_2323_ _1954_ _1955_ VGND VGND VPWR VPWR _2022_ sky130_fd_sc_hd__xnor2_1
XFILLER_69_113 VPWR VGND VPWR VGND sky130_ef_sc_hd__decap_12
X_2254_ net218 net260 net256 net254 VGND VGND VPWR VPWR _1953_ sky130_fd_sc_hd__a22o_1
XTAP_TAPCELL_ROW_68_848 VGND VPWR sky130_fd_sc_hd__tapvpwrvgnd_1
XFILLER_38_500 VPWR VGND VPWR VGND sky130_ef_sc_hd__decap_12
XFILLER_38_533 VGND VGND VPWR VPWR sky130_fd_sc_hd__fill_1
X_2185_ net336 _1892_ net91 VGND VGND VPWR VPWR _0393_ sky130_fd_sc_hd__mux2_1
XFILLER_53_503 VGND VGND VPWR VPWR sky130_fd_sc_hd__fill_1
XFILLER_65_363 VPWR VGND VPWR VGND sky130_ef_sc_hd__decap_12
XFILLER_25_216 VGND VGND VPWR VPWR sky130_fd_sc_hd__decap_8
XFILLER_80_344 VPWR VGND VPWR VGND sky130_ef_sc_hd__decap_12
XFILLER_21_422 VGND VGND VPWR VPWR sky130_fd_sc_hd__decap_6
XTAP_TAPCELL_ROW_23_417 VGND VPWR sky130_fd_sc_hd__tapvpwrvgnd_1
XFILLER_21_455 VGND VGND VPWR VPWR sky130_fd_sc_hd__fill_1
XTAP_TAPCELL_ROW_31_494 VGND VPWR sky130_fd_sc_hd__tapvpwrvgnd_1
XFILLER_4_109 VGND VGND VPWR VPWR sky130_fd_sc_hd__decap_8
X_3708_ _1593_ _1596_ VGND VGND VPWR VPWR _1597_ sky130_fd_sc_hd__or2_1
X_3639_ _1499_ _1524_ VGND VGND VPWR VPWR _1528_ sky130_fd_sc_hd__xnor2_1
XFILLER_88_400 VGND VGND VPWR VPWR sky130_fd_sc_hd__decap_3
XFILLER_0_337 VGND VGND VPWR VPWR sky130_fd_sc_hd__fill_2
XFILLER_88_477 VPWR VGND VPWR VGND sky130_ef_sc_hd__decap_12
XFILLER_75_105 VGND VGND VPWR VPWR sky130_fd_sc_hd__fill_2
XFILLER_84_15 VPWR VGND VPWR VGND sky130_ef_sc_hd__decap_12
XFILLER_29_544 VGND VGND VPWR VPWR sky130_fd_sc_hd__decap_8
XFILLER_83_193 VPWR VGND VPWR VGND sky130_ef_sc_hd__decap_12
XTAP_TAPCELL_ROW_39_572 VGND VPWR sky130_fd_sc_hd__tapvpwrvgnd_1
XFILLER_71_355 VGND VGND VPWR VPWR sky130_fd_sc_hd__decap_6
XFILLER_12_433 VPWR VGND VPWR VGND sky130_ef_sc_hd__decap_12
XFILLER_33_52 VGND VGND VPWR VPWR sky130_fd_sc_hd__decap_4
XFILLER_12_477 VPWR VGND VPWR VGND sky130_ef_sc_hd__decap_12
XPHY_EDGE_ROW_89_Left_183 VGND VGND VPWR VPWR sky130_fd_sc_hd__decap_3
XFILLER_3_153 VGND VGND VPWR VPWR sky130_fd_sc_hd__fill_1
XFILLER_79_433 VGND VGND VPWR VPWR sky130_fd_sc_hd__fill_1
XFILLER_3_164 VGND VGND VPWR VPWR sky130_fd_sc_hd__decap_4
XFILLER_79_488 VPWR VGND VPWR VGND sky130_ef_sc_hd__decap_12
XFILLER_35_503 VGND VGND VPWR VPWR sky130_fd_sc_hd__fill_1
XTAP_TAPCELL_ROW_65_818 VGND VPWR sky130_fd_sc_hd__tapvpwrvgnd_1
X_3990_ net34 net33 _0000_ VGND VGND VPWR VPWR _1847_ sky130_fd_sc_hd__and3_2
XTAP_TAPCELL_ROW_73_895 VGND VPWR sky130_fd_sc_hd__tapvpwrvgnd_1
X_2941_ systolic_unit_0.U_01.acc_1\[1\] systolic_unit_0.U_01.acc_0\[1\] net138 VGND
+ VGND VPWR VPWR _0894_ sky130_fd_sc_hd__mux2_1
XFILLER_30_230 VGND VGND VPWR VPWR sky130_fd_sc_hd__fill_2
XFILLER_88_3 VPWR VGND VPWR VGND sky130_ef_sc_hd__decap_12
X_2872_ systolic_unit_0.U_01.acc_1\[4\] systolic_unit_0.U_01.acc_0\[4\] net138 VGND
+ VGND VPWR VPWR _0825_ sky130_fd_sc_hd__mux2_1
XFILLER_30_296 VPWR VGND VPWR VGND sky130_ef_sc_hd__decap_12
X_4473_ clknet_leaf_30_clk systolic_unit_0.U_10.acc_1\[4\] _0197_ VGND VGND VPWR VPWR
+ systolic_unit_0.out_acc_1_r1\[4\] sky130_fd_sc_hd__dfrtp_1
X_3424_ _1058_ _1344_ VGND VGND VPWR VPWR _1345_ sky130_fd_sc_hd__nand2_1
X_3355_ _1243_ _1261_ _1274_ VGND VGND VPWR VPWR _1276_ sky130_fd_sc_hd__or3b_4
X_2306_ net220 net263 net218 net264 VGND VGND VPWR VPWR _2005_ sky130_fd_sc_hd__a22o_1
X_3286_ net114 net158 VGND VGND VPWR VPWR _1207_ sky130_fd_sc_hd__nand2_1
XFILLER_85_469 VPWR VGND VPWR VGND sky130_ef_sc_hd__decap_12
X_2237_ systolic_unit_0.U_00.acc_1\[11\] systolic_unit_0.U_00.acc_0\[11\] net209 VGND
+ VGND VPWR VPWR _1936_ sky130_fd_sc_hd__mux2_1
X_2168_ systolic_unit_0.out_acc_0_r1\[0\] systolic_unit_0.out_acc_1_r1\[0\] net146
+ VGND VGND VPWR VPWR _1884_ sky130_fd_sc_hd__mux2_1
XFILLER_54_29 VPWR VGND VPWR VGND sky130_ef_sc_hd__decap_12
XTAP_TAPCELL_ROW_36_542 VGND VPWR sky130_fd_sc_hd__tapvpwrvgnd_1
XTAP_TAPCELL_ROW_0_189 VGND VPWR sky130_fd_sc_hd__tapvpwrvgnd_1
XFILLER_21_230 VPWR VGND VPWR VGND sky130_ef_sc_hd__decap_12
XPHY_EDGE_ROW_17_Right_17 VGND VGND VPWR VPWR sky130_fd_sc_hd__decap_3
XFILLER_5_429 VPWR VGND VPWR VGND sky130_ef_sc_hd__decap_12
XTAP_TAPCELL_ROW_8_278 VGND VPWR sky130_fd_sc_hd__tapvpwrvgnd_1
XPHY_EDGE_ROW_26_Right_26 VGND VGND VPWR VPWR sky130_fd_sc_hd__decap_3
XFILLER_88_296 VGND VGND VPWR VPWR sky130_fd_sc_hd__fill_2
XFILLER_76_469 VGND VGND VPWR VPWR sky130_fd_sc_hd__decap_4
XFILLER_28_85 VPWR VGND VPWR VGND sky130_ef_sc_hd__decap_12
XFILLER_56_193 VGND VGND VPWR VPWR sky130_fd_sc_hd__decap_3
XFILLER_44_377 VGND VGND VPWR VPWR sky130_fd_sc_hd__decap_3
XFILLER_44_73 VGND VGND VPWR VPWR sky130_fd_sc_hd__decap_3
XTAP_TAPCELL_ROW_70_865 VGND VPWR sky130_fd_sc_hd__tapvpwrvgnd_1
XPHY_EDGE_ROW_35_Right_35 VGND VGND VPWR VPWR sky130_fd_sc_hd__decap_3
XFILLER_8_278 VPWR VGND VPWR VGND sky130_ef_sc_hd__decap_12
XFILLER_69_81 VPWR VGND VPWR VGND sky130_ef_sc_hd__decap_12
XPHY_EDGE_ROW_44_Right_44 VGND VGND VPWR VPWR sky130_fd_sc_hd__decap_3
X_3140_ _1051_ _1056_ VGND VGND VPWR VPWR _1061_ sky130_fd_sc_hd__xor2_1
XTAP_TAPCELL_ROW_78_943 VGND VPWR sky130_fd_sc_hd__tapvpwrvgnd_1
X_3071_ systolic_unit_0.U_10.acc_1\[14\] systolic_unit_0.U_10.acc_0\[14\] net134 VGND
+ VGND VPWR VPWR _0992_ sky130_fd_sc_hd__mux2_1
XFILLER_82_428 VGND VGND VPWR VPWR sky130_fd_sc_hd__decap_3
XFILLER_23_517 VPWR VGND VPWR VGND sky130_ef_sc_hd__decap_12
XTAP_TAPCELL_ROW_33_512 VGND VPWR sky130_fd_sc_hd__tapvpwrvgnd_1
X_3973_ net98 _1805_ _1838_ VGND VGND VPWR VPWR _0253_ sky130_fd_sc_hd__a21o_1
XPHY_EDGE_ROW_53_Right_53 VGND VGND VPWR VPWR sky130_fd_sc_hd__decap_3
X_2924_ net175 net129 VGND VGND VPWR VPWR _0877_ sky130_fd_sc_hd__nand2_1
X_2855_ _0797_ _0803_ _0801_ VGND VGND VPWR VPWR _0808_ sky130_fd_sc_hd__a21o_1
X_2786_ _0733_ _0734_ VGND VGND VPWR VPWR _0739_ sky130_fd_sc_hd__xnor2_1
X_4456_ clknet_leaf_30_clk _0405_ _0180_ VGND VGND VPWR VPWR net65 sky130_fd_sc_hd__dfrtp_1
XPHY_EDGE_ROW_62_Right_62 VGND VGND VPWR VPWR sky130_fd_sc_hd__decap_3
X_3407_ _1326_ _1301_ _1282_ _1281_ VGND VGND VPWR VPWR _1328_ sky130_fd_sc_hd__a31o_1
X_4387_ clknet_leaf_6_clk _0360_ _0111_ VGND VGND VPWR VPWR systolic_unit_0.U_00.acc_1\[7\]
+ sky130_fd_sc_hd__dfrtp_1
X_3338_ _1244_ _1249_ _1255_ _1256_ VGND VGND VPWR VPWR _1259_ sky130_fd_sc_hd__o211a_1
XTAP_TAPCELL_ROW_5_248 VGND VPWR sky130_fd_sc_hd__tapvpwrvgnd_1
XFILLER_85_255 VGND VGND VPWR VPWR sky130_fd_sc_hd__fill_1
X_3269_ _1176_ _1188_ _1189_ VGND VGND VPWR VPWR _1190_ sky130_fd_sc_hd__nand3_2
XFILLER_73_439 VGND VGND VPWR VPWR sky130_fd_sc_hd__decap_8
XFILLER_38_160 VPWR VGND VPWR VGND sky130_ef_sc_hd__decap_12
XFILLER_45_119 VGND VGND VPWR VPWR sky130_fd_sc_hd__fill_1
XFILLER_81_27 VPWR VGND VPWR VGND sky130_ef_sc_hd__decap_12
XPHY_EDGE_ROW_71_Right_71 VGND VGND VPWR VPWR sky130_fd_sc_hd__decap_3
XFILLER_26_377 VGND VGND VPWR VPWR sky130_fd_sc_hd__fill_1
XFILLER_53_163 VGND VGND VPWR VPWR sky130_fd_sc_hd__decap_4
XFILLER_5_237 VPWR VGND VPWR VGND sky130_ef_sc_hd__decap_12
XFILLER_5_215 VGND VGND VPWR VPWR sky130_fd_sc_hd__decap_8
XPHY_EDGE_ROW_80_Right_80 VGND VGND VPWR VPWR sky130_fd_sc_hd__decap_3
XFILLER_30_64 VGND VGND VPWR VPWR sky130_fd_sc_hd__decap_8
XFILLER_30_97 VGND VGND VPWR VPWR sky130_fd_sc_hd__decap_8
XFILLER_39_84 VGND VGND VPWR VPWR sky130_fd_sc_hd__decap_8
XFILLER_49_447 VGND VGND VPWR VPWR sky130_fd_sc_hd__fill_1
XFILLER_49_458 VGND VGND VPWR VPWR sky130_fd_sc_hd__decap_3
XTAP_TAPCELL_ROW_75_913 VGND VPWR sky130_fd_sc_hd__tapvpwrvgnd_1
XFILLER_91_225 VGND VGND VPWR VPWR sky130_fd_sc_hd__fill_2
XFILLER_17_333 VGND VGND VPWR VPWR sky130_fd_sc_hd__decap_3
XFILLER_29_193 VGND VGND VPWR VPWR sky130_fd_sc_hd__fill_2
XTAP_TAPCELL_ROW_47_648 VGND VPWR sky130_fd_sc_hd__tapvpwrvgnd_1
XFILLER_55_61 VGND VGND VPWR VPWR sky130_fd_sc_hd__fill_1
XTAP_TAPCELL_ROW_83_990 VGND VPWR sky130_fd_sc_hd__tapvpwrvgnd_1
XFILLER_32_347 VPWR VGND VPWR VGND sky130_ef_sc_hd__decap_12
XFILLER_72_6 VPWR VGND VPWR VGND sky130_ef_sc_hd__decap_12
X_2640_ net165 net117 VGND VGND VPWR VPWR _0593_ sky130_fd_sc_hd__nand2_1
X_2571_ _1946_ _0555_ VGND VGND VPWR VPWR _0556_ sky130_fd_sc_hd__and2b_1
XTAP_TAPCELL_ROW_10_294 VGND VPWR sky130_fd_sc_hd__tapvpwrvgnd_1
X_4310_ clknet_leaf_26_clk _0291_ _0034_ VGND VGND VPWR VPWR systolic_unit_0.U_10.acc_1\[2\]
+ sky130_fd_sc_hd__dfrtp_1
XFILLER_4_270 VGND VGND VPWR VPWR sky130_fd_sc_hd__decap_8
X_4241_ net226 VGND VGND VPWR VPWR _0222_ sky130_fd_sc_hd__inv_2
X_4172_ net250 VGND VGND VPWR VPWR _0153_ sky130_fd_sc_hd__inv_2
XTAP_TAPCELL_ROW_2_218 VGND VPWR sky130_fd_sc_hd__tapvpwrvgnd_1
X_3123_ _1042_ _1043_ VGND VGND VPWR VPWR _1044_ sky130_fd_sc_hd__nor2_1
X_3054_ net95 _0974_ net77 net373 VGND VGND VPWR VPWR _0322_ sky130_fd_sc_hd__a22o_1
XTAP_TAPCELL_ROW_18_372 VGND VPWR sky130_fd_sc_hd__tapvpwrvgnd_1
XFILLER_23_325 VGND VGND VPWR VPWR sky130_fd_sc_hd__decap_3
X_3956_ systolic_unit_0.U_11.acc_1\[15\] _1828_ VGND VGND VPWR VPWR _1829_ sky130_fd_sc_hd__or2_1
XFILLER_50_155 VPWR VGND VPWR VGND sky130_ef_sc_hd__decap_12
X_2907_ _0844_ _0859_ VGND VGND VPWR VPWR _0860_ sky130_fd_sc_hd__or2_1
XFILLER_31_391 VGND VGND VPWR VPWR sky130_fd_sc_hd__fill_1
X_3887_ _1495_ _1530_ _1774_ _1497_ VGND VGND VPWR VPWR _1776_ sky130_fd_sc_hd__a31o_1
X_2838_ _0789_ _0790_ VGND VGND VPWR VPWR _0791_ sky130_fd_sc_hd__and2b_1
X_2769_ _0718_ _0721_ VGND VGND VPWR VPWR _0722_ sky130_fd_sc_hd__or2_1
X_4508_ clknet_leaf_8_clk net28 _0232_ VGND VGND VPWR VPWR systolic_unit_0.U_01.in_b\[3\]
+ sky130_fd_sc_hd__dfrtp_1
X_4439_ clknet_leaf_16_clk _0396_ _0163_ VGND VGND VPWR VPWR net58 sky130_fd_sc_hd__dfrtp_1
XTAP_TAPCELL_ROW_92_1079 VGND VPWR sky130_fd_sc_hd__tapvpwrvgnd_1
XFILLER_86_531 VGND VGND VPWR VPWR sky130_fd_sc_hd__fill_1
XFILLER_76_27 VGND VGND VPWR VPWR sky130_fd_sc_hd__fill_1
XFILLER_86_553 VGND VGND VPWR VPWR sky130_fd_sc_hd__fill_1
XFILLER_73_225 VGND VGND VPWR VPWR sky130_fd_sc_hd__decap_8
XFILLER_18_119 VGND VGND VPWR VPWR sky130_fd_sc_hd__decap_6
XFILLER_92_15 VPWR VGND VPWR VGND sky130_ef_sc_hd__decap_12
XFILLER_26_130 VGND VGND VPWR VPWR sky130_fd_sc_hd__decap_6
XTAP_TAPCELL_ROW_44_618 VGND VPWR sky130_fd_sc_hd__tapvpwrvgnd_1
XTAP_TAPCELL_ROW_80_960 VGND VPWR sky130_fd_sc_hd__tapvpwrvgnd_1
XFILLER_22_380 VPWR VGND VPWR VGND sky130_ef_sc_hd__decap_12
XTAP_TAPCELL_ROW_52_695 VGND VPWR sky130_fd_sc_hd__tapvpwrvgnd_1
XFILLER_10_553 VGND VGND VPWR VPWR sky130_fd_sc_hd__fill_1
XFILLER_10_531 VGND VGND VPWR VPWR sky130_fd_sc_hd__fill_1
XFILLER_6_513 VPWR VGND VPWR VGND sky130_ef_sc_hd__decap_12
XFILLER_89_391 VGND VGND VPWR VPWR sky130_fd_sc_hd__fill_1
XFILLER_92_501 VPWR VGND VPWR VGND sky130_ef_sc_hd__decap_12
XFILLER_77_553 VGND VGND VPWR VPWR sky130_fd_sc_hd__fill_1
XFILLER_92_545 VGND VGND VPWR VPWR sky130_fd_sc_hd__decap_8
XTAP_TAPCELL_ROW_15_342 VGND VPWR sky130_fd_sc_hd__tapvpwrvgnd_1
XFILLER_20_306 VGND VGND VPWR VPWR sky130_fd_sc_hd__fill_2
XPHY_EDGE_ROW_25_Left_119 VGND VGND VPWR VPWR sky130_fd_sc_hd__decap_3
X_3810_ _1696_ _1697_ VGND VGND VPWR VPWR _1699_ sky130_fd_sc_hd__xnor2_1
XFILLER_32_177 VGND VGND VPWR VPWR sky130_fd_sc_hd__decap_6
X_3741_ net204 net181 VGND VGND VPWR VPWR _1630_ sky130_fd_sc_hd__and2_1
XFILLER_60_497 VPWR VGND VPWR VGND sky130_ef_sc_hd__decap_12
XFILLER_13_391 VGND VGND VPWR VPWR sky130_fd_sc_hd__fill_1
X_3672_ net200 net178 _1513_ _1514_ VGND VGND VPWR VPWR _1561_ sky130_fd_sc_hd__o2bb2a_1
X_2623_ net99 _0564_ net80 net374 VGND VGND VPWR VPWR _0367_ sky130_fd_sc_hd__a22o_1
X_2554_ _1939_ _1944_ VGND VGND VPWR VPWR _0539_ sky130_fd_sc_hd__xor2_1
XFILLER_87_306 VPWR VGND VPWR VGND sky130_ef_sc_hd__decap_12
XPHY_EDGE_ROW_34_Left_128 VGND VGND VPWR VPWR sky130_fd_sc_hd__decap_3
X_2485_ _0458_ _0459_ _0460_ _0456_ VGND VGND VPWR VPWR _0470_ sky130_fd_sc_hd__a22o_1
X_4224_ net226 VGND VGND VPWR VPWR _0205_ sky130_fd_sc_hd__inv_2
XFILLER_68_553 VGND VGND VPWR VPWR sky130_fd_sc_hd__fill_1
X_4155_ net232 VGND VGND VPWR VPWR _0136_ sky130_fd_sc_hd__inv_2
X_3106_ _1008_ _1026_ VGND VGND VPWR VPWR _1027_ sky130_fd_sc_hd__nor2_1
XFILLER_55_225 VGND VGND VPWR VPWR sky130_fd_sc_hd__fill_1
X_4086_ net238 VGND VGND VPWR VPWR _0067_ sky130_fd_sc_hd__inv_2
XFILLER_36_472 VGND VGND VPWR VPWR sky130_fd_sc_hd__decap_4
X_3037_ net131 net177 _0912_ VGND VGND VPWR VPWR _0975_ sky130_fd_sc_hd__a21o_1
XFILLER_23_100 VGND VGND VPWR VPWR sky130_fd_sc_hd__decap_6
XPHY_EDGE_ROW_43_Left_137 VGND VGND VPWR VPWR sky130_fd_sc_hd__decap_3
XFILLER_11_317 VGND VGND VPWR VPWR sky130_fd_sc_hd__decap_4
X_3939_ systolic_unit_0.U_01.acc_0\[4\] net75 net82 systolic_unit_0.U_11.acc_0\[4\]
+ VGND VGND VPWR VPWR _1817_ sky130_fd_sc_hd__a22o_1
XFILLER_3_505 VPWR VGND VPWR VGND sky130_ef_sc_hd__decap_12
XFILLER_87_15 VPWR VGND VPWR VGND sky130_ef_sc_hd__decap_12
XPHY_EDGE_ROW_52_Left_146 VGND VGND VPWR VPWR sky130_fd_sc_hd__decap_3
XFILLER_78_339 VGND VGND VPWR VPWR sky130_fd_sc_hd__fill_1
XFILLER_93_309 VPWR VGND VPWR VGND sky130_ef_sc_hd__decap_12
XFILLER_74_501 VPWR VGND VPWR VGND sky130_ef_sc_hd__decap_12
XFILLER_46_203 VPWR VGND VPWR VGND sky130_ef_sc_hd__decap_12
XFILLER_74_545 VGND VGND VPWR VPWR sky130_fd_sc_hd__decap_8
XTAP_TAPCELL_ROW_57_743 VGND VPWR sky130_fd_sc_hd__tapvpwrvgnd_1
XFILLER_27_461 VGND VGND VPWR VPWR sky130_fd_sc_hd__decap_6
XTAP_TAPCELL_ROW_29_478 VGND VPWR sky130_fd_sc_hd__tapvpwrvgnd_1
XFILLER_36_41 VGND VGND VPWR VPWR sky130_fd_sc_hd__decap_3
XPHY_EDGE_ROW_61_Left_155 VGND VGND VPWR VPWR sky130_fd_sc_hd__decap_3
XFILLER_27_494 VGND VGND VPWR VPWR sky130_fd_sc_hd__decap_3
XFILLER_36_85 VPWR VGND VPWR VGND sky130_ef_sc_hd__decap_12
XFILLER_42_431 VPWR VGND VPWR VGND sky130_ef_sc_hd__decap_12
XFILLER_42_475 VGND VGND VPWR VPWR sky130_fd_sc_hd__fill_1
XTAP_TAPCELL_ROW_12_312 VGND VPWR sky130_fd_sc_hd__tapvpwrvgnd_1
Xinput27 D_b_01[2] VGND VGND VPWR VPWR net27 sky130_fd_sc_hd__clkbuf_1
Xinput16 D_a_10[7] VGND VGND VPWR VPWR net16 sky130_fd_sc_hd__clkbuf_1
XFILLER_6_321 VPWR VGND VPWR VGND sky130_ef_sc_hd__decap_12
Xinput38 rst VGND VGND VPWR VPWR net38 sky130_fd_sc_hd__clkbuf_1
XPHY_EDGE_ROW_70_Left_164 VGND VGND VPWR VPWR sky130_fd_sc_hd__decap_3
XFILLER_6_365 VPWR VGND VPWR VGND sky130_ef_sc_hd__decap_12
X_2270_ _1966_ _1967_ _1968_ VGND VGND VPWR VPWR _1969_ sky130_fd_sc_hd__nand3_1
XFILLER_77_92 VGND VGND VPWR VPWR sky130_fd_sc_hd__decap_8
XFILLER_37_225 VGND VGND VPWR VPWR sky130_fd_sc_hd__decap_8
XFILLER_52_217 VGND VGND VPWR VPWR sky130_fd_sc_hd__decap_4
XFILLER_18_494 VPWR VGND VPWR VGND sky130_ef_sc_hd__decap_12
XFILLER_20_125 VGND VGND VPWR VPWR sky130_fd_sc_hd__fill_1
X_3724_ _1589_ _1590_ VGND VGND VPWR VPWR _1613_ sky130_fd_sc_hd__xnor2_1
X_3655_ net187 net193 _1543_ _1541_ VGND VGND VPWR VPWR _1544_ sky130_fd_sc_hd__a31o_1
X_2606_ net371 net88 _0581_ net208 VGND VGND VPWR VPWR _0375_ sky130_fd_sc_hd__a22o_1
X_3586_ _1471_ _1473_ _1474_ VGND VGND VPWR VPWR _1475_ sky130_fd_sc_hd__and3_1
X_2537_ _0446_ _0447_ VGND VGND VPWR VPWR _0522_ sky130_fd_sc_hd__nand2_1
XFILLER_87_125 VPWR VGND VPWR VGND sky130_ef_sc_hd__decap_12
X_2468_ net270 net255 net221 net272 VGND VGND VPWR VPWR _0453_ sky130_fd_sc_hd__a22oi_1
XFILLER_87_169 VPWR VGND VPWR VGND sky130_ef_sc_hd__decap_12
X_4207_ net223 VGND VGND VPWR VPWR _0188_ sky130_fd_sc_hd__inv_2
X_2399_ _2095_ _2096_ VGND VGND VPWR VPWR _2098_ sky130_fd_sc_hd__xnor2_1
X_4138_ net230 VGND VGND VPWR VPWR _0119_ sky130_fd_sc_hd__inv_2
XFILLER_83_364 VGND VGND VPWR VPWR sky130_fd_sc_hd__decap_3
X_4069_ net238 VGND VGND VPWR VPWR _0050_ sky130_fd_sc_hd__inv_2
XFILLER_43_206 VPWR VGND VPWR VGND sky130_ef_sc_hd__decap_12
XTAP_TAPCELL_ROW_54_713 VGND VPWR sky130_fd_sc_hd__tapvpwrvgnd_1
XTAP_TAPCELL_ROW_26_448 VGND VPWR sky130_fd_sc_hd__tapvpwrvgnd_1
XFILLER_24_475 VGND VGND VPWR VPWR sky130_fd_sc_hd__fill_1
XFILLER_51_250 VGND VGND VPWR VPWR sky130_fd_sc_hd__fill_2
XTAP_TAPCELL_ROW_62_790 VGND VPWR sky130_fd_sc_hd__tapvpwrvgnd_1
XFILLER_11_169 VPWR VGND VPWR VGND sky130_ef_sc_hd__decap_12
XFILLER_3_302 VPWR VGND VPWR VGND sky130_ef_sc_hd__decap_12
XPHY_EDGE_ROW_5_Left_99 VGND VGND VPWR VPWR sky130_fd_sc_hd__decap_3
XFILLER_0_3 VPWR VGND VPWR VGND sky130_ef_sc_hd__decap_12
XFILLER_78_114 VPWR VGND VPWR VGND sky130_ef_sc_hd__decap_12
Xfanout171 systolic_unit_0.U_00.out_a\[3\] VGND VGND VPWR VPWR net171 sky130_fd_sc_hd__buf_2
Xfanout160 systolic_unit_0.U_00.out_b\[2\] VGND VGND VPWR VPWR net160 sky130_fd_sc_hd__buf_2
Xfanout182 systolic_unit_0.U_01.out_b\[4\] VGND VGND VPWR VPWR net182 sky130_fd_sc_hd__clkbuf_4
Xfanout193 systolic_unit_0.U_10.out_a\[6\] VGND VGND VPWR VPWR net193 sky130_fd_sc_hd__buf_2
XFILLER_19_269 VGND VGND VPWR VPWR sky130_fd_sc_hd__decap_8
XFILLER_47_95 VGND VGND VPWR VPWR sky130_fd_sc_hd__fill_1
XFILLER_62_526 VGND VGND VPWR VPWR sky130_fd_sc_hd__decap_6
XFILLER_42_250 VGND VGND VPWR VPWR sky130_fd_sc_hd__fill_2
XFILLER_42_283 VPWR VGND VPWR VGND sky130_ef_sc_hd__decap_12
XFILLER_30_489 VGND VGND VPWR VPWR sky130_fd_sc_hd__fill_1
XFILLER_10_180 VGND VGND VPWR VPWR sky130_fd_sc_hd__fill_2
X_3440_ _1343_ _1358_ VGND VGND VPWR VPWR _1359_ sky130_fd_sc_hd__xnor2_1
X_3371_ _1287_ _1290_ _1291_ _1266_ VGND VGND VPWR VPWR _1292_ sky130_fd_sc_hd__a211o_1
XFILLER_69_125 VGND VGND VPWR VPWR sky130_fd_sc_hd__fill_2
X_2322_ _2018_ _2019_ _2017_ VGND VGND VPWR VPWR _2021_ sky130_fd_sc_hd__a21boi_1
X_2253_ net254 net218 net260 net256 VGND VGND VPWR VPWR _1952_ sky130_fd_sc_hd__nand4_1
XFILLER_69_169 VGND VGND VPWR VPWR sky130_fd_sc_hd__fill_2
XFILLER_38_512 VPWR VGND VPWR VGND sky130_ef_sc_hd__decap_12
XFILLER_84_139 VGND VGND VPWR VPWR sky130_fd_sc_hd__fill_1
XTAP_TAPCELL_ROW_68_849 VGND VPWR sky130_fd_sc_hd__tapvpwrvgnd_1
X_2184_ systolic_unit_0.U_11.acc_0\[8\] systolic_unit_0.U_11.acc_1\[8\] net150 VGND
+ VGND VPWR VPWR _1892_ sky130_fd_sc_hd__mux2_1
XFILLER_65_375 VPWR VGND VPWR VGND sky130_ef_sc_hd__decap_12
XFILLER_80_356 VGND VGND VPWR VPWR sky130_fd_sc_hd__decap_4
XTAP_TAPCELL_ROW_23_418 VGND VPWR sky130_fd_sc_hd__tapvpwrvgnd_1
XFILLER_21_445 VGND VGND VPWR VPWR sky130_fd_sc_hd__decap_3
XTAP_TAPCELL_ROW_31_495 VGND VPWR sky130_fd_sc_hd__tapvpwrvgnd_1
X_3707_ net205 net178 _1595_ VGND VGND VPWR VPWR _1596_ sky130_fd_sc_hd__and3_1
X_3638_ _1526_ VGND VGND VPWR VPWR _1527_ sky130_fd_sc_hd__inv_2
X_3569_ _1447_ _1448_ _1457_ VGND VGND VPWR VPWR _1458_ sky130_fd_sc_hd__a21o_1
XFILLER_68_39 VPWR VGND VPWR VGND sky130_ef_sc_hd__decap_12
XFILLER_88_489 VPWR VGND VPWR VGND sky130_ef_sc_hd__decap_12
XFILLER_48_309 VGND VGND VPWR VPWR sky130_fd_sc_hd__decap_3
XFILLER_84_27 VGND VGND VPWR VPWR sky130_fd_sc_hd__fill_1
XFILLER_90_109 VPWR VGND VPWR VGND sky130_ef_sc_hd__decap_12
XFILLER_83_161 VGND VGND VPWR VPWR sky130_fd_sc_hd__decap_6
XFILLER_71_312 VPWR VGND VPWR VGND sky130_ef_sc_hd__decap_12
XTAP_TAPCELL_ROW_39_573 VGND VPWR sky130_fd_sc_hd__tapvpwrvgnd_1
XFILLER_71_389 VGND VGND VPWR VPWR sky130_fd_sc_hd__decap_3
XFILLER_12_401 VPWR VGND VPWR VGND sky130_ef_sc_hd__decap_12
XFILLER_12_445 VPWR VGND VPWR VGND sky130_ef_sc_hd__decap_12
XFILLER_12_489 VPWR VGND VPWR VGND sky130_ef_sc_hd__decap_12
XFILLER_79_467 VGND VGND VPWR VPWR sky130_fd_sc_hd__fill_1
XFILLER_47_331 VGND VGND VPWR VPWR sky130_fd_sc_hd__decap_4
XFILLER_59_191 VGND VGND VPWR VPWR sky130_fd_sc_hd__fill_1
XTAP_TAPCELL_ROW_65_819 VGND VPWR sky130_fd_sc_hd__tapvpwrvgnd_1
XFILLER_74_82 VGND VGND VPWR VPWR sky130_fd_sc_hd__fill_2
XTAP_TAPCELL_ROW_73_896 VGND VPWR sky130_fd_sc_hd__tapvpwrvgnd_1
XFILLER_22_209 VGND VGND VPWR VPWR sky130_fd_sc_hd__decap_6
X_2940_ _0877_ _0878_ VGND VGND VPWR VPWR _0893_ sky130_fd_sc_hd__xnor2_1
X_2871_ _0784_ _0785_ VGND VGND VPWR VPWR _0824_ sky130_fd_sc_hd__xnor2_1
XFILLER_30_253 VGND VGND VPWR VPWR sky130_fd_sc_hd__fill_1
X_4472_ clknet_leaf_25_clk net321 _0196_ VGND VGND VPWR VPWR systolic_unit_0.out_acc_1_r1\[3\]
+ sky130_fd_sc_hd__dfrtp_1
X_3423_ _1059_ _1090_ _1342_ VGND VGND VPWR VPWR _1344_ sky130_fd_sc_hd__or3_4
X_3354_ _1243_ _1261_ _1274_ VGND VGND VPWR VPWR _1275_ sky130_fd_sc_hd__nor3b_1
X_2305_ net268 net216 VGND VGND VPWR VPWR _2004_ sky130_fd_sc_hd__and2_1
X_3285_ _1203_ _1204_ _1202_ VGND VGND VPWR VPWR _1206_ sky130_fd_sc_hd__a21bo_1
X_2236_ net261 net215 net257 net218 VGND VGND VPWR VPWR _1935_ sky130_fd_sc_hd__a22o_1
XFILLER_57_128 VGND VGND VPWR VPWR sky130_fd_sc_hd__fill_2
XTAP_TAPCELL_ROW_88_1040 VGND VPWR sky130_fd_sc_hd__tapvpwrvgnd_1
XFILLER_72_109 VPWR VGND VPWR VGND sky130_ef_sc_hd__decap_12
X_2167_ net352 _1883_ net93 VGND VGND VPWR VPWR _0402_ sky130_fd_sc_hd__mux2_1
XTAP_TAPCELL_ROW_36_543 VGND VPWR sky130_fd_sc_hd__tapvpwrvgnd_1
XFILLER_53_345 VGND VGND VPWR VPWR sky130_fd_sc_hd__fill_2
XFILLER_80_153 VGND VGND VPWR VPWR sky130_fd_sc_hd__decap_3
XFILLER_80_197 VPWR VGND VPWR VGND sky130_ef_sc_hd__decap_12
XFILLER_70_29 VPWR VGND VPWR VGND sky130_ef_sc_hd__decap_12
XFILLER_70_18 VGND VGND VPWR VPWR sky130_fd_sc_hd__decap_8
XFILLER_21_242 VGND VGND VPWR VPWR sky130_fd_sc_hd__decap_6
XTAP_TAPCELL_ROW_8_279 VGND VPWR sky130_fd_sc_hd__tapvpwrvgnd_1
XFILLER_0_113 VPWR VGND VPWR VGND sky130_ef_sc_hd__decap_12
XFILLER_88_253 VPWR VGND VPWR VGND sky130_ef_sc_hd__decap_12
XFILLER_28_97 VGND VGND VPWR VPWR sky130_fd_sc_hd__fill_2
XFILLER_56_161 VPWR VGND VPWR VGND sky130_ef_sc_hd__decap_12
XFILLER_44_334 VGND VGND VPWR VPWR sky130_fd_sc_hd__decap_3
XFILLER_12_220 VGND VGND VPWR VPWR sky130_fd_sc_hd__decap_8
XTAP_TAPCELL_ROW_70_866 VGND VPWR sky130_fd_sc_hd__tapvpwrvgnd_1
XFILLER_12_253 VGND VGND VPWR VPWR sky130_fd_sc_hd__decap_3
XFILLER_8_246 VGND VGND VPWR VPWR sky130_fd_sc_hd__decap_3
XFILLER_5_57 VPWR VGND VPWR VGND sky130_ef_sc_hd__decap_12
XFILLER_69_93 VGND VGND VPWR VPWR sky130_fd_sc_hd__decap_8
XTAP_TAPCELL_ROW_78_944 VGND VPWR sky130_fd_sc_hd__tapvpwrvgnd_1
X_3070_ _0989_ _0990_ VGND VGND VPWR VPWR _0991_ sky130_fd_sc_hd__nor2_1
XFILLER_85_81 VPWR VGND VPWR VGND sky130_ef_sc_hd__decap_12
XFILLER_90_440 VPWR VGND VPWR VGND sky130_ef_sc_hd__decap_12
XFILLER_23_529 VPWR VGND VPWR VGND sky130_ef_sc_hd__decap_12
XTAP_TAPCELL_ROW_33_513 VGND VPWR sky130_fd_sc_hd__tapvpwrvgnd_1
X_3972_ systolic_unit_0.U_11.acc_1\[8\] net74 _1830_ systolic_unit_0.U_01.acc_1\[8\]
+ VGND VGND VPWR VPWR _1838_ sky130_fd_sc_hd__a22o_1
XFILLER_62_197 VGND VGND VPWR VPWR sky130_fd_sc_hd__decap_4
X_2923_ net130 net173 _0874_ VGND VGND VPWR VPWR _0876_ sky130_fd_sc_hd__and3_1
X_2854_ _0806_ _0778_ VGND VGND VPWR VPWR _0807_ sky130_fd_sc_hd__nand2b_1
X_2785_ _0737_ VGND VGND VPWR VPWR _0738_ sky130_fd_sc_hd__inv_2
XTAP_TAPCELL_ROW_41_590 VGND VPWR sky130_fd_sc_hd__tapvpwrvgnd_1
X_4455_ clknet_leaf_25_clk _0404_ _0179_ VGND VGND VPWR VPWR net64 sky130_fd_sc_hd__dfrtp_1
X_3406_ _1301_ _1326_ VGND VGND VPWR VPWR _1327_ sky130_fd_sc_hd__nand2_1
X_4386_ clknet_leaf_0_clk _0359_ _0110_ VGND VGND VPWR VPWR systolic_unit_0.U_00.acc_1\[6\]
+ sky130_fd_sc_hd__dfrtp_1
X_3337_ _1257_ VGND VGND VPWR VPWR _1258_ sky130_fd_sc_hd__inv_2
XFILLER_85_223 VGND VGND VPWR VPWR sky130_fd_sc_hd__fill_1
XTAP_TAPCELL_ROW_5_249 VGND VPWR sky130_fd_sc_hd__tapvpwrvgnd_1
X_3268_ _1138_ _1175_ _1174_ VGND VGND VPWR VPWR _1189_ sky130_fd_sc_hd__a21bo_1
XFILLER_65_18 VPWR VGND VPWR VGND sky130_ef_sc_hd__decap_12
X_2219_ net258 net212 VGND VGND VPWR VPWR _1918_ sky130_fd_sc_hd__nand2_1
X_3199_ _1115_ _1118_ _1119_ VGND VGND VPWR VPWR _1120_ sky130_fd_sc_hd__and3_1
XFILLER_38_172 VPWR VGND VPWR VGND sky130_ef_sc_hd__decap_12
XFILLER_14_529 VGND VGND VPWR VPWR sky130_fd_sc_hd__decap_3
XFILLER_81_39 VGND VGND VPWR VPWR sky130_fd_sc_hd__decap_8
XFILLER_41_337 VGND VGND VPWR VPWR sky130_fd_sc_hd__fill_1
XFILLER_41_359 VGND VGND VPWR VPWR sky130_fd_sc_hd__fill_2
XFILLER_5_249 VPWR VGND VPWR VGND sky130_ef_sc_hd__decap_12
XFILLER_39_74 VGND VGND VPWR VPWR sky130_fd_sc_hd__fill_1
XTAP_TAPCELL_ROW_75_914 VGND VPWR sky130_fd_sc_hd__tapvpwrvgnd_1
XTAP_TAPCELL_ROW_47_649 VGND VPWR sky130_fd_sc_hd__tapvpwrvgnd_1
XFILLER_55_73 VGND VGND VPWR VPWR sky130_fd_sc_hd__fill_1
XTAP_TAPCELL_ROW_83_991 VGND VPWR sky130_fd_sc_hd__tapvpwrvgnd_1
XFILLER_44_197 VGND VGND VPWR VPWR sky130_fd_sc_hd__fill_2
XFILLER_32_359 VGND VGND VPWR VPWR sky130_fd_sc_hd__decap_4
XFILLER_65_6 VPWR VGND VPWR VGND sky130_ef_sc_hd__decap_12
X_2570_ _1923_ _1942_ _1945_ VGND VGND VPWR VPWR _0555_ sky130_fd_sc_hd__nand3b_1
XTAP_TAPCELL_ROW_10_295 VGND VPWR sky130_fd_sc_hd__tapvpwrvgnd_1
X_4240_ net226 VGND VGND VPWR VPWR _0221_ sky130_fd_sc_hd__inv_2
X_4171_ net250 VGND VGND VPWR VPWR _0152_ sky130_fd_sc_hd__inv_2
X_3122_ net157 net103 net102 net159 VGND VGND VPWR VPWR _1043_ sky130_fd_sc_hd__a22oi_1
XTAP_TAPCELL_ROW_2_219 VGND VPWR sky130_fd_sc_hd__tapvpwrvgnd_1
XFILLER_27_109 VGND VGND VPWR VPWR sky130_fd_sc_hd__decap_3
XFILLER_48_481 VGND VGND VPWR VPWR sky130_fd_sc_hd__fill_1
X_3053_ net95 _0972_ net77 net365 VGND VGND VPWR VPWR _0323_ sky130_fd_sc_hd__a22o_1
XTAP_TAPCELL_ROW_85_1010 VGND VPWR sky130_fd_sc_hd__tapvpwrvgnd_1
XTAP_TAPCELL_ROW_18_373 VGND VPWR sky130_fd_sc_hd__tapvpwrvgnd_1
X_3955_ net74 VGND VGND VPWR VPWR _1828_ sky130_fd_sc_hd__inv_2
X_2906_ _0857_ _0858_ _0852_ VGND VGND VPWR VPWR _0859_ sky130_fd_sc_hd__a21boi_1
XFILLER_50_167 VGND VGND VPWR VPWR sky130_fd_sc_hd__decap_4
X_3886_ _1530_ _1774_ VGND VGND VPWR VPWR _1775_ sky130_fd_sc_hd__nand2_1
X_2837_ net171 net124 net169 net126 VGND VGND VPWR VPWR _0790_ sky130_fd_sc_hd__a22o_1
X_2768_ net175 net118 _0720_ VGND VGND VPWR VPWR _0721_ sky130_fd_sc_hd__and3_1
X_4507_ clknet_leaf_8_clk net27 _0231_ VGND VGND VPWR VPWR systolic_unit_0.U_01.in_b\[2\]
+ sky130_fd_sc_hd__dfrtp_1
X_2699_ net170 net117 _0621_ _0622_ VGND VGND VPWR VPWR _0652_ sky130_fd_sc_hd__o2bb2a_1
X_4438_ clknet_leaf_22_clk _0395_ _0162_ VGND VGND VPWR VPWR net57 sky130_fd_sc_hd__dfrtp_1
X_4369_ clknet_leaf_12_clk _0342_ _0093_ VGND VGND VPWR VPWR systolic_unit_0.U_01.acc_0\[5\]
+ sky130_fd_sc_hd__dfrtp_1
XFILLER_46_407 VPWR VGND VPWR VGND sky130_ef_sc_hd__decap_12
XFILLER_92_27 VGND VGND VPWR VPWR sky130_fd_sc_hd__fill_1
XTAP_TAPCELL_ROW_44_619 VGND VPWR sky130_fd_sc_hd__tapvpwrvgnd_1
XFILLER_81_292 VGND VGND VPWR VPWR sky130_fd_sc_hd__decap_4
XFILLER_81_281 VGND VGND VPWR VPWR sky130_fd_sc_hd__decap_4
XTAP_TAPCELL_ROW_80_961 VGND VPWR sky130_fd_sc_hd__tapvpwrvgnd_1
XFILLER_41_156 VGND VGND VPWR VPWR sky130_fd_sc_hd__fill_1
XTAP_TAPCELL_ROW_52_696 VGND VPWR sky130_fd_sc_hd__tapvpwrvgnd_1
XFILLER_22_392 VGND VGND VPWR VPWR sky130_fd_sc_hd__decap_6
XFILLER_6_525 VGND VGND VPWR VPWR sky130_fd_sc_hd__decap_6
XFILLER_89_370 VGND VGND VPWR VPWR sky130_fd_sc_hd__fill_1
XFILLER_49_223 VGND VGND VPWR VPWR sky130_fd_sc_hd__fill_1
XFILLER_1_296 VGND VGND VPWR VPWR sky130_fd_sc_hd__fill_1
XFILLER_92_513 VPWR VGND VPWR VGND sky130_ef_sc_hd__decap_12
XTAP_TAPCELL_ROW_15_343 VGND VPWR sky130_fd_sc_hd__tapvpwrvgnd_1
X_3740_ _1613_ _1628_ VGND VGND VPWR VPWR _1629_ sky130_fd_sc_hd__or2_1
X_3671_ _1556_ _1559_ VGND VGND VPWR VPWR _1560_ sky130_fd_sc_hd__or2_1
X_2622_ net100 _0563_ net80 net416 VGND VGND VPWR VPWR _0368_ sky130_fd_sc_hd__a22o_1
XFILLER_63_3 VGND VGND VPWR VPWR sky130_fd_sc_hd__fill_1
X_2553_ _2034_ _0531_ _0534_ _0537_ _2073_ VGND VGND VPWR VPWR _0538_ sky130_fd_sc_hd__a41o_2
XFILLER_87_318 VGND VGND VPWR VPWR sky130_fd_sc_hd__decap_8
X_2484_ _0462_ _0463_ _0458_ VGND VGND VPWR VPWR _0469_ sky130_fd_sc_hd__o21ai_1
X_4223_ net223 VGND VGND VPWR VPWR _0204_ sky130_fd_sc_hd__inv_2
X_4154_ net232 VGND VGND VPWR VPWR _0135_ sky130_fd_sc_hd__inv_2
X_4085_ net238 VGND VGND VPWR VPWR _0066_ sky130_fd_sc_hd__inv_2
X_3105_ _1021_ _1025_ _1010_ VGND VGND VPWR VPWR _1026_ sky130_fd_sc_hd__a21o_1
X_3036_ net394 net84 _0974_ net138 VGND VGND VPWR VPWR _0338_ sky130_fd_sc_hd__a22o_1
XFILLER_63_281 VPWR VGND VPWR VGND sky130_ef_sc_hd__decap_12
XFILLER_51_432 VGND VGND VPWR VPWR sky130_fd_sc_hd__fill_1
XFILLER_51_487 VGND VGND VPWR VPWR sky130_fd_sc_hd__fill_1
X_3938_ _1720_ _1815_ VGND VGND VPWR VPWR _1816_ sky130_fd_sc_hd__xnor2_1
X_3869_ _1695_ _1700_ _1737_ _1754_ VGND VGND VPWR VPWR _1758_ sky130_fd_sc_hd__a211o_1
XFILLER_3_517 VPWR VGND VPWR VGND sky130_ef_sc_hd__decap_12
XFILLER_87_27 VPWR VGND VPWR VGND sky130_ef_sc_hd__decap_12
XFILLER_78_307 VGND VGND VPWR VPWR sky130_fd_sc_hd__fill_1
XFILLER_74_513 VPWR VGND VPWR VGND sky130_ef_sc_hd__decap_12
XFILLER_46_215 VGND VGND VPWR VPWR sky130_fd_sc_hd__decap_6
XFILLER_46_226 VGND VGND VPWR VPWR sky130_fd_sc_hd__fill_1
XTAP_TAPCELL_ROW_57_744 VGND VPWR sky130_fd_sc_hd__tapvpwrvgnd_1
XTAP_TAPCELL_ROW_29_479 VGND VPWR sky130_fd_sc_hd__tapvpwrvgnd_1
XFILLER_36_64 VGND VGND VPWR VPWR sky130_fd_sc_hd__fill_2
XFILLER_36_97 VPWR VGND VPWR VGND sky130_ef_sc_hd__decap_12
XFILLER_42_421 VGND VGND VPWR VPWR sky130_fd_sc_hd__fill_1
XFILLER_42_443 VGND VGND VPWR VPWR sky130_fd_sc_hd__decap_8
XTAP_TAPCELL_ROW_12_313 VGND VPWR sky130_fd_sc_hd__tapvpwrvgnd_1
XFILLER_52_85 VPWR VGND VPWR VGND sky130_ef_sc_hd__decap_12
Xinput28 D_b_01[3] VGND VGND VPWR VPWR net28 sky130_fd_sc_hd__clkbuf_1
XFILLER_10_351 VGND VGND VPWR VPWR sky130_fd_sc_hd__decap_6
Xinput17 D_b_00[0] VGND VGND VPWR VPWR net17 sky130_fd_sc_hd__clkbuf_1
XFILLER_6_333 VPWR VGND VPWR VGND sky130_ef_sc_hd__decap_12
XFILLER_6_377 VPWR VGND VPWR VGND sky130_ef_sc_hd__decap_12
XTAP_TAPCELL_ROW_20_390 VGND VPWR sky130_fd_sc_hd__tapvpwrvgnd_1
XFILLER_65_502 VGND VGND VPWR VPWR sky130_fd_sc_hd__fill_2
XFILLER_92_321 VPWR VGND VPWR VGND sky130_ef_sc_hd__decap_12
XFILLER_92_365 VPWR VGND VPWR VGND sky130_ef_sc_hd__decap_12
XFILLER_93_81 VGND VGND VPWR VPWR sky130_fd_sc_hd__decap_3
XFILLER_18_473 VGND VGND VPWR VPWR sky130_fd_sc_hd__decap_3
X_3723_ _1603_ _1604_ VGND VGND VPWR VPWR _1612_ sky130_fd_sc_hd__xor2_1
X_3654_ _1539_ _1540_ VGND VGND VPWR VPWR _1543_ sky130_fd_sc_hd__xnor2_1
X_2605_ _0468_ _0520_ VGND VGND VPWR VPWR _0581_ sky130_fd_sc_hd__xnor2_1
X_3585_ systolic_unit_0.U_11.acc_1\[10\] systolic_unit_0.U_11.acc_0\[10\] net150 VGND
+ VGND VPWR VPWR _1474_ sky130_fd_sc_hd__mux2_1
X_2536_ _0488_ _0519_ _0468_ VGND VGND VPWR VPWR _0521_ sky130_fd_sc_hd__or3b_1
X_2467_ net272 net270 net255 net221 VGND VGND VPWR VPWR _0452_ sky130_fd_sc_hd__and4_1
XFILLER_87_137 VPWR VGND VPWR VGND sky130_ef_sc_hd__decap_12
X_4206_ net223 VGND VGND VPWR VPWR _0187_ sky130_fd_sc_hd__inv_2
X_2398_ _2095_ _2096_ VGND VGND VPWR VPWR _2097_ sky130_fd_sc_hd__nand2_1
XFILLER_83_321 VGND VGND VPWR VPWR sky130_fd_sc_hd__fill_1
X_4137_ net233 VGND VGND VPWR VPWR _0118_ sky130_fd_sc_hd__inv_2
XFILLER_71_505 VPWR VGND VPWR VGND sky130_ef_sc_hd__decap_12
X_4068_ net228 VGND VGND VPWR VPWR _0049_ sky130_fd_sc_hd__inv_2
XFILLER_24_421 VGND VGND VPWR VPWR sky130_fd_sc_hd__decap_8
XFILLER_43_218 VGND VGND VPWR VPWR sky130_fd_sc_hd__decap_6
XTAP_TAPCELL_ROW_54_714 VGND VPWR sky130_fd_sc_hd__tapvpwrvgnd_1
X_3019_ systolic_unit_0.U_01.acc_0\[8\] net85 _0964_ net140 VGND VGND VPWR VPWR _0345_
+ sky130_fd_sc_hd__a22o_1
XTAP_TAPCELL_ROW_26_449 VGND VPWR sky130_fd_sc_hd__tapvpwrvgnd_1
XFILLER_11_104 VGND VGND VPWR VPWR sky130_fd_sc_hd__decap_3
XTAP_TAPCELL_ROW_62_791 VGND VPWR sky130_fd_sc_hd__tapvpwrvgnd_1
XFILLER_22_99 VPWR VGND VPWR VGND sky130_ef_sc_hd__decap_12
XFILLER_3_314 VGND VGND VPWR VPWR sky130_fd_sc_hd__fill_2
XFILLER_78_126 VPWR VGND VPWR VGND sky130_ef_sc_hd__decap_12
Xfanout172 systolic_unit_0.U_00.out_a\[3\] VGND VGND VPWR VPWR net172 sky130_fd_sc_hd__buf_1
Xfanout161 net162 VGND VGND VPWR VPWR net161 sky130_fd_sc_hd__buf_2
Xfanout183 systolic_unit_0.U_01.out_b\[3\] VGND VGND VPWR VPWR net183 sky130_fd_sc_hd__clkbuf_2
Xfanout150 net151 VGND VGND VPWR VPWR net150 sky130_fd_sc_hd__buf_2
XFILLER_74_321 VPWR VGND VPWR VGND sky130_ef_sc_hd__decap_12
Xfanout194 net195 VGND VGND VPWR VPWR net194 sky130_fd_sc_hd__clkbuf_2
XFILLER_27_281 VPWR VGND VPWR VGND sky130_ef_sc_hd__decap_12
XFILLER_6_141 VPWR VGND VPWR VGND sky130_ef_sc_hd__decap_12
XFILLER_6_130 VGND VGND VPWR VPWR sky130_fd_sc_hd__decap_3
X_3370_ _1263_ _1264_ _1265_ VGND VGND VPWR VPWR _1291_ sky130_fd_sc_hd__a21oi_1
X_2321_ _2017_ _2018_ _2019_ VGND VGND VPWR VPWR _2020_ sky130_fd_sc_hd__and3_1
X_2252_ _1949_ _1950_ VGND VGND VPWR VPWR _1951_ sky130_fd_sc_hd__xnor2_1
XFILLER_77_181 VGND VGND VPWR VPWR sky130_fd_sc_hd__decap_4
XFILLER_38_524 VGND VGND VPWR VPWR sky130_fd_sc_hd__decap_4
X_2183_ net342 _1891_ net91 VGND VGND VPWR VPWR _0394_ sky130_fd_sc_hd__mux2_1
XFILLER_65_387 VGND VGND VPWR VPWR sky130_fd_sc_hd__decap_4
XFILLER_92_195 VGND VGND VPWR VPWR sky130_fd_sc_hd__fill_1
XTAP_TAPCELL_ROW_23_419 VGND VPWR sky130_fd_sc_hd__tapvpwrvgnd_1
X_3706_ _1593_ _1594_ VGND VGND VPWR VPWR _1595_ sky130_fd_sc_hd__nor2_1
XTAP_TAPCELL_ROW_31_496 VGND VPWR sky130_fd_sc_hd__tapvpwrvgnd_1
X_3637_ _1516_ _1520_ _1519_ VGND VGND VPWR VPWR _1526_ sky130_fd_sc_hd__a21o_1
X_3568_ _1449_ _1456_ VGND VGND VPWR VPWR _1457_ sky130_fd_sc_hd__nor2_1
X_2519_ net274 net270 net267 net273 VGND VGND VPWR VPWR _0504_ sky130_fd_sc_hd__a22o_1
XFILLER_88_457 VGND VGND VPWR VPWR sky130_fd_sc_hd__decap_3
X_3499_ drain_odd net96 VGND VGND VPWR VPWR _1404_ sky130_fd_sc_hd__or2_1
XFILLER_17_11 VGND VGND VPWR VPWR sky130_fd_sc_hd__decap_3
XFILLER_71_324 VGND VGND VPWR VPWR sky130_fd_sc_hd__decap_4
XTAP_TAPCELL_ROW_39_574 VGND VPWR sky130_fd_sc_hd__tapvpwrvgnd_1
XFILLER_71_335 VGND VGND VPWR VPWR sky130_fd_sc_hd__fill_1
XFILLER_17_77 VPWR VGND VPWR VGND sky130_ef_sc_hd__decap_12
XFILLER_24_251 VGND VGND VPWR VPWR sky130_fd_sc_hd__fill_1
XFILLER_12_413 VGND VGND VPWR VPWR sky130_fd_sc_hd__decap_6
XFILLER_12_457 VPWR VGND VPWR VGND sky130_ef_sc_hd__decap_12
XFILLER_3_111 VGND VGND VPWR VPWR sky130_fd_sc_hd__fill_1
XFILLER_79_446 VGND VGND VPWR VPWR sky130_fd_sc_hd__fill_2
XFILLER_58_62 VGND VGND VPWR VPWR sky130_fd_sc_hd__fill_1
XFILLER_59_181 VGND VGND VPWR VPWR sky130_fd_sc_hd__fill_1
XFILLER_47_343 VGND VGND VPWR VPWR sky130_fd_sc_hd__fill_1
XTAP_TAPCELL_ROW_73_897 VGND VPWR sky130_fd_sc_hd__tapvpwrvgnd_1
XFILLER_15_251 VPWR VGND VPWR VGND sky130_ef_sc_hd__decap_12
X_2870_ _0792_ _0793_ VGND VGND VPWR VPWR _0823_ sky130_fd_sc_hd__xnor2_1
XFILLER_15_273 VGND VGND VPWR VPWR sky130_fd_sc_hd__decap_6
XFILLER_30_243 VGND VGND VPWR VPWR sky130_fd_sc_hd__decap_8
Xclkbuf_leaf_10_clk clknet_2_2__leaf_clk VGND VGND VPWR VPWR clknet_leaf_10_clk sky130_fd_sc_hd__clkbuf_8
X_4471_ clknet_leaf_25_clk net320 _0195_ VGND VGND VPWR VPWR systolic_unit_0.out_acc_1_r1\[2\]
+ sky130_fd_sc_hd__dfrtp_1
XFILLER_7_461 VPWR VGND VPWR VGND sky130_ef_sc_hd__decap_12
X_3422_ _1090_ _1342_ VGND VGND VPWR VPWR _1343_ sky130_fd_sc_hd__or2_1
X_3353_ _1262_ _1272_ _1273_ VGND VGND VPWR VPWR _1274_ sky130_fd_sc_hd__and3_4
X_2304_ net264 net220 net263 net218 VGND VGND VPWR VPWR _2003_ sky130_fd_sc_hd__nand4_1
X_3284_ _1202_ _1203_ _1204_ VGND VGND VPWR VPWR _1205_ sky130_fd_sc_hd__and3_1
XFILLER_85_438 VGND VGND VPWR VPWR sky130_fd_sc_hd__fill_2
X_2235_ net218 net261 net214 net256 VGND VGND VPWR VPWR _1934_ sky130_fd_sc_hd__nand4_1
XTAP_TAPCELL_ROW_88_1041 VGND VPWR sky130_fd_sc_hd__tapvpwrvgnd_1
XFILLER_26_505 VGND VGND VPWR VPWR sky130_fd_sc_hd__fill_1
X_2166_ systolic_unit_0.out_acc_0_r1\[1\] systolic_unit_0.out_acc_1_r1\[1\] net151
+ VGND VGND VPWR VPWR _1883_ sky130_fd_sc_hd__mux2_1
XFILLER_65_173 VGND VGND VPWR VPWR sky130_fd_sc_hd__fill_1
XTAP_TAPCELL_ROW_36_544 VGND VPWR sky130_fd_sc_hd__tapvpwrvgnd_1
XFILLER_53_335 VGND VGND VPWR VPWR sky130_fd_sc_hd__fill_1
XFILLER_61_390 VGND VGND VPWR VPWR sky130_fd_sc_hd__fill_2
XPHY_EDGE_ROW_3_Right_3 VGND VGND VPWR VPWR sky130_fd_sc_hd__decap_3
X_2999_ net412 net84 _0951_ net139 VGND VGND VPWR VPWR _0352_ sky130_fd_sc_hd__a22o_1
XFILLER_88_232 VGND VGND VPWR VPWR sky130_fd_sc_hd__fill_2
XFILLER_0_125 VPWR VGND VPWR VGND sky130_ef_sc_hd__decap_12
XFILLER_0_169 VPWR VGND VPWR VGND sky130_ef_sc_hd__decap_12
XFILLER_28_32 VGND VGND VPWR VPWR sky130_fd_sc_hd__fill_2
XFILLER_29_310 VGND VGND VPWR VPWR sky130_fd_sc_hd__fill_2
XFILLER_28_43 VGND VGND VPWR VPWR sky130_fd_sc_hd__fill_1
XFILLER_29_343 VPWR VGND VPWR VGND sky130_ef_sc_hd__decap_12
XFILLER_17_505 VPWR VGND VPWR VGND sky130_ef_sc_hd__decap_12
XFILLER_28_76 VGND VGND VPWR VPWR sky130_fd_sc_hd__decap_8
XFILLER_56_173 VPWR VGND VPWR VGND sky130_ef_sc_hd__decap_12
XFILLER_71_110 VGND VGND VPWR VPWR sky130_fd_sc_hd__fill_2
XFILLER_71_143 VGND VGND VPWR VPWR sky130_fd_sc_hd__fill_1
XTAP_TAPCELL_ROW_70_867 VGND VPWR sky130_fd_sc_hd__tapvpwrvgnd_1
XFILLER_40_552 VGND VGND VPWR VPWR sky130_fd_sc_hd__fill_2
XFILLER_60_85 VGND VGND VPWR VPWR sky130_fd_sc_hd__decap_4
XFILLER_5_69 VPWR VGND VPWR VGND sky130_ef_sc_hd__decap_12
XFILLER_4_475 VGND VGND VPWR VPWR sky130_fd_sc_hd__fill_1
XTAP_TAPCELL_ROW_78_945 VGND VPWR sky130_fd_sc_hd__tapvpwrvgnd_1
XFILLER_67_449 VPWR VGND VPWR VGND sky130_ef_sc_hd__decap_12
XFILLER_85_93 VPWR VGND VPWR VGND sky130_ef_sc_hd__decap_12
XFILLER_82_419 VGND VGND VPWR VPWR sky130_fd_sc_hd__fill_1
XFILLER_90_452 VPWR VGND VPWR VGND sky130_ef_sc_hd__decap_12
X_3971_ net98 _1803_ _1837_ VGND VGND VPWR VPWR _0254_ sky130_fd_sc_hd__a21o_1
X_2922_ net130 net173 VGND VGND VPWR VPWR _0875_ sky130_fd_sc_hd__nand2_1
XTAP_TAPCELL_ROW_33_514 VGND VPWR sky130_fd_sc_hd__tapvpwrvgnd_1
XFILLER_62_187 VGND VGND VPWR VPWR sky130_fd_sc_hd__decap_8
XFILLER_93_3 VPWR VGND VPWR VGND sky130_ef_sc_hd__decap_12
XFILLER_31_530 VPWR VGND VPWR VGND sky130_ef_sc_hd__decap_12
X_2853_ _0804_ _0805_ _0795_ VGND VGND VPWR VPWR _0806_ sky130_fd_sc_hd__o21a_1
X_2784_ _0695_ _0699_ _0732_ _0735_ VGND VGND VPWR VPWR _0737_ sky130_fd_sc_hd__a211oi_2
XTAP_TAPCELL_ROW_41_591 VGND VPWR sky130_fd_sc_hd__tapvpwrvgnd_1
X_4454_ clknet_leaf_25_clk _0403_ _0178_ VGND VGND VPWR VPWR net61 sky130_fd_sc_hd__dfrtp_1
X_3405_ _1280_ _1284_ _1298_ _1325_ VGND VGND VPWR VPWR _1326_ sky130_fd_sc_hd__a31o_1
X_4385_ clknet_leaf_5_clk _0358_ _0109_ VGND VGND VPWR VPWR systolic_unit_0.U_00.acc_1\[5\]
+ sky130_fd_sc_hd__dfrtp_1
X_3336_ _1255_ _1256_ _1244_ _1249_ VGND VGND VPWR VPWR _1257_ sky130_fd_sc_hd__a211o_1
X_3267_ _1181_ _1186_ VGND VGND VPWR VPWR _1188_ sky130_fd_sc_hd__xnor2_1
XFILLER_85_279 VGND VGND VPWR VPWR sky130_fd_sc_hd__fill_1
X_2218_ _1915_ _1916_ VGND VGND VPWR VPWR _1917_ sky130_fd_sc_hd__nor2_1
X_3198_ _1078_ _1103_ _1114_ VGND VGND VPWR VPWR _1119_ sky130_fd_sc_hd__a21o_1
X_2149_ net344 _1874_ systolic_unit_0.drain_valid VGND VGND VPWR VPWR _0411_ sky130_fd_sc_hd__mux2_1
XFILLER_38_184 VPWR VGND VPWR VGND sky130_ef_sc_hd__decap_12
XFILLER_81_474 VPWR VGND VPWR VGND sky130_ef_sc_hd__decap_12
XFILLER_41_305 VPWR VGND VPWR VGND sky130_ef_sc_hd__decap_12
XFILLER_22_530 VGND VGND VPWR VPWR sky130_fd_sc_hd__fill_2
XFILLER_30_11 VGND VGND VPWR VPWR sky130_fd_sc_hd__fill_1
XFILLER_89_541 VPWR VGND VPWR VGND sky130_ef_sc_hd__decap_12
XFILLER_76_246 VGND VGND VPWR VPWR sky130_fd_sc_hd__decap_6
XFILLER_64_408 VGND VGND VPWR VPWR sky130_fd_sc_hd__fill_2
XFILLER_91_205 VPWR VGND VPWR VGND sky130_ef_sc_hd__decap_12
XTAP_TAPCELL_ROW_75_915 VGND VPWR sky130_fd_sc_hd__tapvpwrvgnd_1
XFILLER_72_463 VGND VGND VPWR VPWR sky130_fd_sc_hd__fill_1
XTAP_TAPCELL_ROW_83_992 VGND VPWR sky130_fd_sc_hd__tapvpwrvgnd_1
XFILLER_32_338 VGND VGND VPWR VPWR sky130_fd_sc_hd__fill_2
XFILLER_44_176 VPWR VGND VPWR VGND sky130_ef_sc_hd__decap_12
XFILLER_13_541 VPWR VGND VPWR VGND sky130_ef_sc_hd__decap_12
XFILLER_71_73 VGND VGND VPWR VPWR sky130_fd_sc_hd__decap_3
XTAP_TAPCELL_ROW_10_296 VGND VPWR sky130_fd_sc_hd__tapvpwrvgnd_1
X_4170_ net235 VGND VGND VPWR VPWR _0151_ sky130_fd_sc_hd__inv_2
X_3121_ net159 net157 net103 net101 VGND VGND VPWR VPWR _1042_ sky130_fd_sc_hd__and4_1
XFILLER_48_471 VGND VGND VPWR VPWR sky130_fd_sc_hd__decap_4
X_3052_ net95 _0971_ net77 net389 VGND VGND VPWR VPWR _0324_ sky130_fd_sc_hd__a22o_1
XTAP_TAPCELL_ROW_85_1011 VGND VPWR sky130_fd_sc_hd__tapvpwrvgnd_1
XTAP_TAPCELL_ROW_18_374 VGND VPWR sky130_fd_sc_hd__tapvpwrvgnd_1
XFILLER_35_176 VGND VGND VPWR VPWR sky130_fd_sc_hd__fill_2
X_3954_ systolic_unit_0.U_01.drain_1 net97 VGND VGND VPWR VPWR _1827_ sky130_fd_sc_hd__nor2_2
X_2905_ _0845_ _0851_ VGND VGND VPWR VPWR _0858_ sky130_fd_sc_hd__xor2_2
X_3885_ _1770_ _1771_ _1773_ _1532_ VGND VGND VPWR VPWR _1774_ sky130_fd_sc_hd__a31o_1
X_2836_ net126 net171 net124 net169 VGND VGND VPWR VPWR _0789_ sky130_fd_sc_hd__and4_1
X_2767_ _0718_ _0719_ VGND VGND VPWR VPWR _0720_ sky130_fd_sc_hd__nor2_1
X_2698_ net172 net118 _0649_ _0647_ VGND VGND VPWR VPWR _0651_ sky130_fd_sc_hd__a31o_1
X_4506_ clknet_leaf_8_clk net26 _0230_ VGND VGND VPWR VPWR systolic_unit_0.U_01.in_b\[1\]
+ sky130_fd_sc_hd__dfrtp_1
X_4437_ clknet_leaf_16_clk _0394_ _0161_ VGND VGND VPWR VPWR net56 sky130_fd_sc_hd__dfrtp_1
XFILLER_86_533 VPWR VGND VPWR VGND sky130_ef_sc_hd__decap_12
XFILLER_58_202 VPWR VGND VPWR VGND sky130_ef_sc_hd__decap_12
X_4368_ clknet_leaf_12_clk _0341_ _0092_ VGND VGND VPWR VPWR systolic_unit_0.U_01.acc_0\[4\]
+ sky130_fd_sc_hd__dfrtp_1
X_3319_ _1237_ _1238_ _1230_ VGND VGND VPWR VPWR _1240_ sky130_fd_sc_hd__a21o_1
X_4299_ clknet_leaf_18_clk _0280_ _0023_ VGND VGND VPWR VPWR systolic_unit_0.U_11.acc_0\[7\]
+ sky130_fd_sc_hd__dfrtp_1
XFILLER_39_471 VPWR VGND VPWR VGND sky130_ef_sc_hd__decap_12
XFILLER_46_419 VGND VGND VPWR VPWR sky130_fd_sc_hd__fill_1
XFILLER_14_316 VPWR VGND VPWR VGND sky130_ef_sc_hd__decap_12
XFILLER_54_485 VGND VGND VPWR VPWR sky130_fd_sc_hd__fill_1
XTAP_TAPCELL_ROW_80_962 VGND VPWR sky130_fd_sc_hd__tapvpwrvgnd_1
XFILLER_25_55 VGND VGND VPWR VPWR sky130_fd_sc_hd__fill_1
XFILLER_10_533 VPWR VGND VPWR VGND sky130_ef_sc_hd__decap_12
XTAP_TAPCELL_ROW_52_697 VGND VPWR sky130_fd_sc_hd__tapvpwrvgnd_1
XFILLER_41_43 VGND VGND VPWR VPWR sky130_fd_sc_hd__fill_1
XFILLER_2_15 VPWR VGND VPWR VGND sky130_ef_sc_hd__decap_12
XFILLER_89_393 VPWR VGND VPWR VGND sky130_ef_sc_hd__decap_12
XFILLER_92_525 VGND VGND VPWR VPWR sky130_fd_sc_hd__decap_6
XFILLER_17_143 VPWR VGND VPWR VGND sky130_ef_sc_hd__decap_12
XFILLER_82_83 VGND VGND VPWR VPWR sky130_fd_sc_hd__fill_1
XTAP_TAPCELL_ROW_15_344 VGND VPWR sky130_fd_sc_hd__tapvpwrvgnd_1
XFILLER_13_393 VPWR VGND VPWR VGND sky130_ef_sc_hd__decap_12
X_3670_ net202 net178 _1558_ VGND VGND VPWR VPWR _1559_ sky130_fd_sc_hd__and3_1
XFILLER_9_353 VGND VGND VPWR VPWR sky130_fd_sc_hd__fill_1
X_2621_ net100 drain_odd VGND VGND VPWR VPWR _0590_ sky130_fd_sc_hd__nor2_1
X_2552_ _0536_ VGND VGND VPWR VPWR _0537_ sky130_fd_sc_hd__inv_2
X_4222_ net225 VGND VGND VPWR VPWR _0203_ sky130_fd_sc_hd__inv_2
X_2483_ _0449_ _0465_ VGND VGND VPWR VPWR _0468_ sky130_fd_sc_hd__xnor2_2
XTAP_TAPCELL_ROW_91_1070 VGND VPWR sky130_fd_sc_hd__tapvpwrvgnd_1
XFILLER_68_533 VPWR VGND VPWR VGND sky130_ef_sc_hd__decap_12
X_4153_ net223 VGND VGND VPWR VPWR _0134_ sky130_fd_sc_hd__inv_2
XFILLER_83_503 VGND VGND VPWR VPWR sky130_fd_sc_hd__fill_1
X_4084_ net238 VGND VGND VPWR VPWR _0065_ sky130_fd_sc_hd__inv_2
X_3104_ _1023_ _1024_ VGND VGND VPWR VPWR _1025_ sky130_fd_sc_hd__nand2_1
X_3035_ _0916_ _0973_ VGND VGND VPWR VPWR _0974_ sky130_fd_sc_hd__nor2_1
XFILLER_36_441 VGND VGND VPWR VPWR sky130_fd_sc_hd__fill_2
XFILLER_36_485 VGND VGND VPWR VPWR sky130_fd_sc_hd__fill_2
XFILLER_51_444 VGND VGND VPWR VPWR sky130_fd_sc_hd__decap_4
XFILLER_63_293 VGND VGND VPWR VPWR sky130_fd_sc_hd__decap_8
X_3937_ _1733_ _1750_ VGND VGND VPWR VPWR _1815_ sky130_fd_sc_hd__nand2_1
X_3868_ _1753_ _1756_ VGND VGND VPWR VPWR _1757_ sky130_fd_sc_hd__nor2_1
X_2819_ _0721_ _0762_ _0763_ _0766_ VGND VGND VPWR VPWR _0772_ sky130_fd_sc_hd__o31ai_2
X_3799_ net204 net182 _1682_ _1681_ VGND VGND VPWR VPWR _1688_ sky130_fd_sc_hd__a31o_1
XFILLER_11_57 VPWR VGND VPWR VGND sky130_ef_sc_hd__decap_12
XFILLER_3_529 VPWR VGND VPWR VGND sky130_ef_sc_hd__decap_12
XFILLER_87_39 VPWR VGND VPWR VGND sky130_ef_sc_hd__decap_12
XFILLER_59_511 VGND VGND VPWR VPWR sky130_fd_sc_hd__decap_8
XFILLER_86_363 VGND VGND VPWR VPWR sky130_fd_sc_hd__fill_1
XFILLER_74_525 VGND VGND VPWR VPWR sky130_fd_sc_hd__decap_6
XTAP_TAPCELL_ROW_57_745 VGND VPWR sky130_fd_sc_hd__tapvpwrvgnd_1
XFILLER_36_76 VGND VGND VPWR VPWR sky130_fd_sc_hd__decap_8
XTAP_TAPCELL_ROW_12_314 VGND VPWR sky130_fd_sc_hd__tapvpwrvgnd_1
XFILLER_52_97 VPWR VGND VPWR VGND sky130_ef_sc_hd__decap_12
Xinput18 D_b_00[1] VGND VGND VPWR VPWR net18 sky130_fd_sc_hd__buf_1
Xinput29 D_b_01[4] VGND VGND VPWR VPWR net29 sky130_fd_sc_hd__clkbuf_1
XFILLER_6_345 VPWR VGND VPWR VGND sky130_ef_sc_hd__decap_12
XTAP_TAPCELL_ROW_20_391 VGND VPWR sky130_fd_sc_hd__tapvpwrvgnd_1
XFILLER_6_389 VPWR VGND VPWR VGND sky130_ef_sc_hd__decap_12
XFILLER_37_205 VGND VGND VPWR VPWR sky130_fd_sc_hd__fill_2
XFILLER_92_333 VGND VGND VPWR VPWR sky130_fd_sc_hd__decap_8
XFILLER_37_216 VGND VGND VPWR VPWR sky130_fd_sc_hd__decap_3
XFILLER_80_506 VPWR VGND VPWR VGND sky130_ef_sc_hd__decap_12
XFILLER_92_377 VPWR VGND VPWR VGND sky130_ef_sc_hd__decap_12
XFILLER_33_400 VPWR VGND VPWR VGND sky130_ef_sc_hd__decap_12
XFILLER_60_241 VGND VGND VPWR VPWR sky130_fd_sc_hd__decap_8
X_3722_ _1574_ _1609_ VGND VGND VPWR VPWR _1611_ sky130_fd_sc_hd__xnor2_1
X_3653_ net187 net193 VGND VGND VPWR VPWR _1542_ sky130_fd_sc_hd__nand2_1
X_2604_ systolic_unit_0.U_00.acc_0\[7\] net88 _0580_ net208 VGND VGND VPWR VPWR _0376_
+ sky130_fd_sc_hd__a22o_1
X_3584_ _1445_ _1472_ VGND VGND VPWR VPWR _1473_ sky130_fd_sc_hd__nand2b_1
X_2535_ _0488_ _0519_ VGND VGND VPWR VPWR _0520_ sky130_fd_sc_hd__or2_1
XFILLER_87_105 VGND VGND VPWR VPWR sky130_fd_sc_hd__decap_6
X_2466_ _0422_ _0426_ _0425_ VGND VGND VPWR VPWR _0451_ sky130_fd_sc_hd__a21o_1
XFILLER_87_149 VPWR VGND VPWR VGND sky130_ef_sc_hd__decap_12
X_4205_ net222 VGND VGND VPWR VPWR _0186_ sky130_fd_sc_hd__inv_2
X_4136_ net232 VGND VGND VPWR VPWR _0117_ sky130_fd_sc_hd__inv_2
X_2397_ _2056_ _2057_ VGND VGND VPWR VPWR _2096_ sky130_fd_sc_hd__xnor2_1
XFILLER_56_536 VGND VGND VPWR VPWR sky130_fd_sc_hd__fill_2
X_4067_ net228 VGND VGND VPWR VPWR _0048_ sky130_fd_sc_hd__inv_2
X_3018_ _0926_ _0931_ VGND VGND VPWR VPWR _0964_ sky130_fd_sc_hd__xnor2_1
XFILLER_71_517 VPWR VGND VPWR VGND sky130_ef_sc_hd__decap_12
XFILLER_36_260 VGND VGND VPWR VPWR sky130_fd_sc_hd__decap_6
XTAP_TAPCELL_ROW_54_715 VGND VPWR sky130_fd_sc_hd__tapvpwrvgnd_1
XFILLER_36_282 VGND VGND VPWR VPWR sky130_fd_sc_hd__decap_4
XFILLER_36_293 VPWR VGND VPWR VGND sky130_ef_sc_hd__decap_12
XTAP_TAPCELL_ROW_62_792 VGND VPWR sky130_fd_sc_hd__tapvpwrvgnd_1
XFILLER_22_23 VGND VGND VPWR VPWR sky130_fd_sc_hd__fill_2
XFILLER_78_138 VGND VGND VPWR VPWR sky130_fd_sc_hd__fill_2
Xfanout140 net141 VGND VGND VPWR VPWR net140 sky130_fd_sc_hd__buf_2
Xfanout173 systolic_unit_0.U_00.out_a\[2\] VGND VGND VPWR VPWR net173 sky130_fd_sc_hd__buf_2
Xfanout162 systolic_unit_0.U_00.out_b\[1\] VGND VGND VPWR VPWR net162 sky130_fd_sc_hd__buf_2
Xfanout151 systolic_unit_0.U_11.switch VGND VGND VPWR VPWR net151 sky130_fd_sc_hd__buf_2
XFILLER_74_333 VPWR VGND VPWR VGND sky130_ef_sc_hd__decap_12
XFILLER_19_238 VGND VGND VPWR VPWR sky130_fd_sc_hd__decap_3
Xfanout195 systolic_unit_0.U_10.out_a\[5\] VGND VGND VPWR VPWR net195 sky130_fd_sc_hd__buf_2
Xfanout184 systolic_unit_0.U_01.out_b\[3\] VGND VGND VPWR VPWR net184 sky130_fd_sc_hd__buf_1
XFILLER_74_377 VPWR VGND VPWR VGND sky130_ef_sc_hd__decap_12
XFILLER_27_260 VGND VGND VPWR VPWR sky130_fd_sc_hd__decap_4
XFILLER_27_293 VPWR VGND VPWR VGND sky130_ef_sc_hd__decap_12
XFILLER_42_230 VPWR VGND VPWR VGND sky130_ef_sc_hd__decap_12
XFILLER_63_74 VPWR VGND VPWR VGND sky130_ef_sc_hd__decap_12
XFILLER_6_153 VGND VGND VPWR VPWR sky130_fd_sc_hd__decap_3
XFILLER_6_164 VGND VGND VPWR VPWR sky130_fd_sc_hd__fill_2
XFILLER_6_197 VPWR VGND VPWR VGND sky130_ef_sc_hd__decap_12
X_2320_ systolic_unit_0.U_00.acc_1\[8\] systolic_unit_0.U_00.acc_0\[8\] net208 VGND
+ VGND VPWR VPWR _2019_ sky130_fd_sc_hd__mux2_1
X_2251_ systolic_unit_0.U_00.acc_1\[10\] systolic_unit_0.U_00.acc_0\[10\] net209 VGND
+ VGND VPWR VPWR _1950_ sky130_fd_sc_hd__mux2_1
XFILLER_19_3 VPWR VGND VPWR VGND sky130_ef_sc_hd__decap_12
X_2182_ systolic_unit_0.U_11.acc_0\[9\] systolic_unit_0.U_11.acc_1\[9\] net147 VGND
+ VGND VPWR VPWR _1891_ sky130_fd_sc_hd__mux2_1
XFILLER_92_141 VPWR VGND VPWR VGND sky130_ef_sc_hd__decap_12
XFILLER_80_303 VGND VGND VPWR VPWR sky130_fd_sc_hd__decap_4
XFILLER_33_274 VGND VGND VPWR VPWR sky130_fd_sc_hd__decap_3
X_3705_ net200 net181 net180 net202 VGND VGND VPWR VPWR _1594_ sky130_fd_sc_hd__a22oi_1
XTAP_TAPCELL_ROW_31_497 VGND VPWR sky130_fd_sc_hd__tapvpwrvgnd_1
X_3636_ _1499_ _1524_ VGND VGND VPWR VPWR _1525_ sky130_fd_sc_hd__nand2_1
X_3567_ _1454_ _1455_ VGND VGND VPWR VPWR _1456_ sky130_fd_sc_hd__nand2_1
XFILLER_88_425 VPWR VGND VPWR VGND sky130_ef_sc_hd__decap_12
X_2518_ _0496_ _0502_ VGND VGND VPWR VPWR _0503_ sky130_fd_sc_hd__nor2_1
XFILLER_0_329 VGND VGND VPWR VPWR sky130_fd_sc_hd__decap_3
X_3498_ drain_odd _1868_ VGND VGND VPWR VPWR _1403_ sky130_fd_sc_hd__nor2_2
X_2449_ _0432_ _0433_ VGND VGND VPWR VPWR _0434_ sky130_fd_sc_hd__nand2_1
XFILLER_84_29 VPWR VGND VPWR VGND sky130_ef_sc_hd__decap_12
X_4119_ net251 VGND VGND VPWR VPWR _0100_ sky130_fd_sc_hd__inv_2
XTAP_TAPCELL_ROW_67_840 VGND VPWR sky130_fd_sc_hd__tapvpwrvgnd_1
XTAP_TAPCELL_ROW_39_575 VGND VPWR sky130_fd_sc_hd__tapvpwrvgnd_1
XFILLER_12_469 VGND VGND VPWR VPWR sky130_fd_sc_hd__decap_6
XFILLER_8_407 VPWR VGND VPWR VGND sky130_ef_sc_hd__decap_12
XPHY_EDGE_ROW_49_Left_143 VGND VGND VPWR VPWR sky130_fd_sc_hd__decap_3
XPHY_EDGE_ROW_58_Left_152 VGND VGND VPWR VPWR sky130_fd_sc_hd__decap_3
XFILLER_58_41 VGND VGND VPWR VPWR sky130_fd_sc_hd__decap_8
XFILLER_58_85 VGND VGND VPWR VPWR sky130_fd_sc_hd__fill_2
XFILLER_59_160 VGND VGND VPWR VPWR sky130_fd_sc_hd__fill_2
XFILLER_74_141 VGND VGND VPWR VPWR sky130_fd_sc_hd__decap_8
XFILLER_74_152 VPWR VGND VPWR VGND sky130_ef_sc_hd__decap_12
XFILLER_50_509 VGND VGND VPWR VPWR sky130_fd_sc_hd__decap_3
XTAP_TAPCELL_ROW_73_898 VGND VPWR sky130_fd_sc_hd__tapvpwrvgnd_1
XFILLER_15_263 VGND VGND VPWR VPWR sky130_fd_sc_hd__decap_4
XPHY_EDGE_ROW_67_Left_161 VGND VGND VPWR VPWR sky130_fd_sc_hd__decap_3
XFILLER_90_83 VGND VGND VPWR VPWR sky130_fd_sc_hd__fill_1
XFILLER_30_288 VGND VGND VPWR VPWR sky130_fd_sc_hd__fill_2
XFILLER_7_473 VPWR VGND VPWR VGND sky130_ef_sc_hd__decap_12
X_4470_ clknet_leaf_27_clk net301 _0194_ VGND VGND VPWR VPWR systolic_unit_0.out_acc_1_r1\[1\]
+ sky130_fd_sc_hd__dfrtp_1
X_3421_ _1165_ _1339_ _1338_ _1341_ _1163_ VGND VGND VPWR VPWR _1342_ sky130_fd_sc_hd__o311a_4
X_3352_ _1271_ _1270_ _1267_ VGND VGND VPWR VPWR _1273_ sky130_fd_sc_hd__a21o_1
X_2303_ _1982_ _1984_ _1983_ VGND VGND VPWR VPWR _2002_ sky130_fd_sc_hd__o21ai_1
XPHY_EDGE_ROW_76_Left_170 VGND VGND VPWR VPWR sky130_fd_sc_hd__decap_3
X_3283_ systolic_unit_0.U_10.acc_1\[5\] systolic_unit_0.U_10.acc_0\[5\] net135 VGND
+ VGND VPWR VPWR _1204_ sky130_fd_sc_hd__mux2_2
X_2234_ _1911_ _1932_ VGND VGND VPWR VPWR _1933_ sky130_fd_sc_hd__nor2_1
XTAP_TAPCELL_ROW_88_1042 VGND VPWR sky130_fd_sc_hd__tapvpwrvgnd_1
X_2165_ net357 _1882_ net93 VGND VGND VPWR VPWR _0403_ sky130_fd_sc_hd__mux2_1
XFILLER_93_461 VPWR VGND VPWR VGND sky130_ef_sc_hd__decap_12
XTAP_TAPCELL_ROW_64_810 VGND VPWR sky130_fd_sc_hd__tapvpwrvgnd_1
XFILLER_0_81 VGND VGND VPWR VPWR sky130_fd_sc_hd__decap_3
XTAP_TAPCELL_ROW_36_545 VGND VPWR sky130_fd_sc_hd__tapvpwrvgnd_1
XFILLER_21_211 VPWR VGND VPWR VGND sky130_ef_sc_hd__decap_12
X_2998_ _0945_ _0950_ VGND VGND VPWR VPWR _0951_ sky130_fd_sc_hd__xnor2_1
XFILLER_21_266 VGND VGND VPWR VPWR sky130_fd_sc_hd__decap_8
XFILLER_21_288 VGND VGND VPWR VPWR sky130_fd_sc_hd__decap_6
X_3619_ _1506_ _1507_ net182 net194 VGND VGND VPWR VPWR _1508_ sky130_fd_sc_hd__and4bb_1
XFILLER_0_137 VGND VGND VPWR VPWR sky130_fd_sc_hd__decap_3
XFILLER_88_288 VGND VGND VPWR VPWR sky130_fd_sc_hd__decap_8
XFILLER_29_322 VPWR VGND VPWR VGND sky130_ef_sc_hd__decap_12
XFILLER_29_355 VPWR VGND VPWR VGND sky130_ef_sc_hd__decap_12
XFILLER_17_517 VPWR VGND VPWR VGND sky130_ef_sc_hd__decap_12
XFILLER_56_185 VGND VGND VPWR VPWR sky130_fd_sc_hd__decap_8
XFILLER_40_520 VGND VGND VPWR VPWR sky130_fd_sc_hd__decap_8
XFILLER_44_65 VGND VGND VPWR VPWR sky130_fd_sc_hd__decap_8
XTAP_TAPCELL_ROW_70_868 VGND VPWR sky130_fd_sc_hd__tapvpwrvgnd_1
XFILLER_40_542 VGND VGND VPWR VPWR sky130_fd_sc_hd__fill_2
XFILLER_5_15 VPWR VGND VPWR VGND sky130_ef_sc_hd__decap_12
XFILLER_4_421 VPWR VGND VPWR VGND sky130_ef_sc_hd__decap_12
XTAP_TAPCELL_ROW_78_946 VGND VPWR sky130_fd_sc_hd__tapvpwrvgnd_1
XTAP_TAPCELL_ROW_7_270 VGND VPWR sky130_fd_sc_hd__tapvpwrvgnd_1
XPHY_EDGE_ROW_13_Right_13 VGND VGND VPWR VPWR sky130_fd_sc_hd__decap_3
XFILLER_75_461 VGND VGND VPWR VPWR sky130_fd_sc_hd__fill_2
XFILLER_90_464 VPWR VGND VPWR VGND sky130_ef_sc_hd__decap_12
X_3970_ systolic_unit_0.U_11.acc_1\[9\] _1827_ _1830_ systolic_unit_0.U_01.acc_1\[9\]
+ VGND VGND VPWR VPWR _1837_ sky130_fd_sc_hd__a22o_1
XTAP_TAPCELL_ROW_33_515 VGND VPWR sky130_fd_sc_hd__tapvpwrvgnd_1
XFILLER_43_380 VGND VGND VPWR VPWR sky130_fd_sc_hd__decap_6
X_2921_ systolic_unit_0.U_01.acc_1\[2\] systolic_unit_0.U_01.acc_0\[2\] net138 VGND
+ VGND VPWR VPWR _0874_ sky130_fd_sc_hd__mux2_1
XFILLER_31_542 VPWR VGND VPWR VGND sky130_ef_sc_hd__decap_12
XFILLER_86_3 VPWR VGND VPWR VGND sky130_ef_sc_hd__decap_12
X_2852_ _0779_ _0794_ VGND VGND VPWR VPWR _0805_ sky130_fd_sc_hd__xnor2_1
X_2783_ _0732_ _0735_ _0695_ _0699_ VGND VGND VPWR VPWR _0736_ sky130_fd_sc_hd__o211a_1
XPHY_EDGE_ROW_22_Right_22 VGND VGND VPWR VPWR sky130_fd_sc_hd__decap_3
XTAP_TAPCELL_ROW_41_592 VGND VPWR sky130_fd_sc_hd__tapvpwrvgnd_1
X_4453_ clknet_leaf_25_clk _0402_ _0177_ VGND VGND VPWR VPWR net50 sky130_fd_sc_hd__dfrtp_1
X_3404_ _1299_ _1302_ _1324_ VGND VGND VPWR VPWR _1325_ sky130_fd_sc_hd__and3_1
X_4384_ clknet_leaf_4_clk _0357_ _0108_ VGND VGND VPWR VPWR systolic_unit_0.U_00.acc_1\[4\]
+ sky130_fd_sc_hd__dfrtp_1
X_3335_ _1252_ _1253_ _1215_ _1217_ VGND VGND VPWR VPWR _1256_ sky130_fd_sc_hd__o211ai_1
XFILLER_85_225 VPWR VGND VPWR VGND sky130_ef_sc_hd__decap_12
X_3266_ _1181_ _1186_ VGND VGND VPWR VPWR _1187_ sky130_fd_sc_hd__nand2b_1
XPHY_EDGE_ROW_31_Right_31 VGND VGND VPWR VPWR sky130_fd_sc_hd__decap_3
X_2217_ _1903_ _1914_ VGND VGND VPWR VPWR _1916_ sky130_fd_sc_hd__and2_1
X_3197_ _1100_ _1117_ VGND VGND VPWR VPWR _1118_ sky130_fd_sc_hd__and2_1
XFILLER_38_141 VPWR VGND VPWR VGND sky130_ef_sc_hd__decap_12
X_2148_ systolic_unit_0.out_acc_0_r1\[10\] systolic_unit_0.out_acc_1_r1\[10\] net143
+ VGND VGND VPWR VPWR _1874_ sky130_fd_sc_hd__mux2_1
XTAP_TAPCELL_ROW_49_670 VGND VPWR sky130_fd_sc_hd__tapvpwrvgnd_1
XFILLER_53_111 VGND VGND VPWR VPWR sky130_fd_sc_hd__fill_1
XFILLER_14_509 VPWR VGND VPWR VGND sky130_ef_sc_hd__decap_12
XFILLER_53_133 VGND VGND VPWR VPWR sky130_fd_sc_hd__fill_2
XFILLER_81_486 VPWR VGND VPWR VGND sky130_ef_sc_hd__decap_12
XFILLER_41_317 VPWR VGND VPWR VGND sky130_ef_sc_hd__decap_12
XFILLER_22_553 VGND VGND VPWR VPWR sky130_fd_sc_hd__fill_1
XFILLER_14_57 VPWR VGND VPWR VGND sky130_ef_sc_hd__decap_12
XPHY_EDGE_ROW_40_Right_40 VGND VGND VPWR VPWR sky130_fd_sc_hd__decap_3
XFILLER_89_553 VGND VGND VPWR VPWR sky130_fd_sc_hd__fill_1
XFILLER_39_32 VGND VGND VPWR VPWR sky130_fd_sc_hd__fill_2
XFILLER_39_54 VGND VGND VPWR VPWR sky130_fd_sc_hd__fill_2
XTAP_TAPCELL_ROW_4_240 VGND VPWR sky130_fd_sc_hd__tapvpwrvgnd_1
XFILLER_91_217 VGND VGND VPWR VPWR sky130_fd_sc_hd__decap_6
XTAP_TAPCELL_ROW_75_916 VGND VPWR sky130_fd_sc_hd__tapvpwrvgnd_1
XFILLER_29_141 VGND VGND VPWR VPWR sky130_fd_sc_hd__decap_4
XFILLER_57_461 VGND VGND VPWR VPWR sky130_fd_sc_hd__decap_6
XTAP_TAPCELL_ROW_83_993 VGND VPWR sky130_fd_sc_hd__tapvpwrvgnd_1
XFILLER_44_188 VGND VGND VPWR VPWR sky130_fd_sc_hd__fill_1
XFILLER_13_553 VGND VGND VPWR VPWR sky130_fd_sc_hd__fill_1
XFILLER_71_41 VGND VGND VPWR VPWR sky130_fd_sc_hd__fill_1
XTAP_TAPCELL_ROW_10_297 VGND VPWR sky130_fd_sc_hd__tapvpwrvgnd_1
X_3120_ _1016_ _1035_ _1040_ VGND VGND VPWR VPWR _1041_ sky130_fd_sc_hd__or3_1
XFILLER_67_225 VPWR VGND VPWR VGND sky130_ef_sc_hd__decap_12
X_3051_ net95 _0969_ net77 net415 VGND VGND VPWR VPWR _0325_ sky130_fd_sc_hd__a22o_1
XTAP_TAPCELL_ROW_85_1012 VGND VPWR sky130_fd_sc_hd__tapvpwrvgnd_1
XTAP_TAPCELL_ROW_46_640 VGND VPWR sky130_fd_sc_hd__tapvpwrvgnd_1
XTAP_TAPCELL_ROW_18_375 VGND VPWR sky130_fd_sc_hd__tapvpwrvgnd_1
XFILLER_23_317 VGND VGND VPWR VPWR sky130_fd_sc_hd__decap_8
X_3953_ systolic_unit_0.U_01.acc_0\[0\] _1785_ _1788_ net397 _1826_ VGND VGND VPWR
+ VPWR _0273_ sky130_fd_sc_hd__o221a_1
X_2904_ _0853_ _0856_ VGND VGND VPWR VPWR _0857_ sky130_fd_sc_hd__xnor2_2
X_3884_ _1533_ _1572_ _1772_ VGND VGND VPWR VPWR _1773_ sky130_fd_sc_hd__a21o_1
X_2835_ net173 net122 VGND VGND VPWR VPWR _0788_ sky130_fd_sc_hd__nand2_1
X_2766_ net172 net120 net119 net174 VGND VGND VPWR VPWR _0719_ sky130_fd_sc_hd__a22oi_1
X_2697_ net171 net117 VGND VGND VPWR VPWR _0650_ sky130_fd_sc_hd__nand2_1
X_4505_ clknet_leaf_8_clk net25 _0229_ VGND VGND VPWR VPWR systolic_unit_0.U_01.in_b\[0\]
+ sky130_fd_sc_hd__dfrtp_1
X_4436_ clknet_leaf_22_clk _0393_ _0160_ VGND VGND VPWR VPWR net55 sky130_fd_sc_hd__dfrtp_1
X_4367_ clknet_leaf_12_clk _0340_ _0091_ VGND VGND VPWR VPWR systolic_unit_0.U_01.acc_0\[3\]
+ sky130_fd_sc_hd__dfrtp_1
XFILLER_86_501 VPWR VGND VPWR VGND sky130_ef_sc_hd__decap_12
X_3318_ _1230_ _1237_ _1238_ VGND VGND VPWR VPWR _1239_ sky130_fd_sc_hd__nand3_1
XFILLER_58_214 VGND VGND VPWR VPWR sky130_fd_sc_hd__fill_1
XFILLER_86_545 VGND VGND VPWR VPWR sky130_fd_sc_hd__decap_8
X_4298_ clknet_leaf_21_clk _0279_ _0022_ VGND VGND VPWR VPWR systolic_unit_0.U_11.acc_0\[6\]
+ sky130_fd_sc_hd__dfrtp_1
X_3249_ net160 net107 _1168_ _1169_ VGND VGND VPWR VPWR _1170_ sky130_fd_sc_hd__a22o_1
XTAP_TAPCELL_ROW_1_210 VGND VPWR sky130_fd_sc_hd__tapvpwrvgnd_1
XFILLER_39_483 VPWR VGND VPWR VGND sky130_ef_sc_hd__decap_12
XFILLER_92_29 VPWR VGND VPWR VGND sky130_ef_sc_hd__decap_12
XFILLER_26_155 VGND VGND VPWR VPWR sky130_fd_sc_hd__fill_1
XFILLER_14_328 VPWR VGND VPWR VGND sky130_ef_sc_hd__decap_12
XFILLER_54_475 VGND VGND VPWR VPWR sky130_fd_sc_hd__fill_1
XTAP_TAPCELL_ROW_80_963 VGND VPWR sky130_fd_sc_hd__tapvpwrvgnd_1
XFILLER_10_501 VPWR VGND VPWR VGND sky130_ef_sc_hd__decap_12
XFILLER_41_11 VGND VGND VPWR VPWR sky130_fd_sc_hd__fill_1
XTAP_TAPCELL_ROW_52_698 VGND VPWR sky130_fd_sc_hd__tapvpwrvgnd_1
XFILLER_10_545 VGND VGND VPWR VPWR sky130_fd_sc_hd__decap_8
XFILLER_41_88 VPWR VGND VPWR VGND sky130_ef_sc_hd__decap_12
XFILLER_89_361 VGND VGND VPWR VPWR sky130_fd_sc_hd__fill_2
XFILLER_2_27 VGND VGND VPWR VPWR sky130_fd_sc_hd__fill_1
XFILLER_49_225 VGND VGND VPWR VPWR sky130_fd_sc_hd__decap_4
XFILLER_66_85 VGND VGND VPWR VPWR sky130_fd_sc_hd__decap_4
XFILLER_17_155 VGND VGND VPWR VPWR sky130_fd_sc_hd__decap_6
XTAP_TAPCELL_ROW_43_610 VGND VPWR sky130_fd_sc_hd__tapvpwrvgnd_1
XFILLER_60_412 VGND VGND VPWR VPWR sky130_fd_sc_hd__decap_3
XFILLER_60_445 VGND VGND VPWR VPWR sky130_fd_sc_hd__fill_1
XTAP_TAPCELL_ROW_15_345 VGND VPWR sky130_fd_sc_hd__tapvpwrvgnd_1
XFILLER_13_361 VPWR VGND VPWR VGND sky130_ef_sc_hd__decap_12
XFILLER_70_6 VPWR VGND VPWR VGND sky130_ef_sc_hd__decap_12
X_2620_ net210 _0512_ _0589_ net89 net369 VGND VGND VPWR VPWR _0369_ sky130_fd_sc_hd__a32o_1
X_2551_ _2069_ _2071_ _2035_ VGND VGND VPWR VPWR _0536_ sky130_fd_sc_hd__o21a_1
X_2482_ _0446_ _0466_ _0447_ VGND VGND VPWR VPWR _0467_ sky130_fd_sc_hd__a21bo_1
X_4221_ net222 VGND VGND VPWR VPWR _0202_ sky130_fd_sc_hd__inv_2
XFILLER_49_3 VGND VGND VPWR VPWR sky130_fd_sc_hd__decap_3
XFILLER_68_545 VGND VGND VPWR VPWR sky130_fd_sc_hd__decap_8
X_4152_ net233 VGND VGND VPWR VPWR _0133_ sky130_fd_sc_hd__inv_2
X_4083_ net238 VGND VGND VPWR VPWR _0064_ sky130_fd_sc_hd__inv_2
X_3103_ systolic_unit_0.U_10.acc_1\[12\] systolic_unit_0.U_10.acc_0\[12\] net133 VGND
+ VGND VPWR VPWR _1024_ sky130_fd_sc_hd__mux2_1
X_3034_ _0911_ _0914_ VGND VGND VPWR VPWR _0973_ sky130_fd_sc_hd__nor2_1
XFILLER_70_209 VGND VGND VPWR VPWR sky130_fd_sc_hd__fill_2
XFILLER_63_272 VGND VGND VPWR VPWR sky130_fd_sc_hd__decap_3
XFILLER_23_136 VGND VGND VPWR VPWR sky130_fd_sc_hd__decap_3
XFILLER_23_169 VPWR VGND VPWR VGND sky130_ef_sc_hd__decap_12
XFILLER_51_467 VGND VGND VPWR VPWR sky130_fd_sc_hd__decap_3
X_3936_ net144 _1813_ _1814_ VGND VGND VPWR VPWR _0278_ sky130_fd_sc_hd__a21o_1
XPHY_EDGE_ROW_12_Left_106 VGND VGND VPWR VPWR sky130_fd_sc_hd__decap_3
X_3867_ _1737_ _1754_ VGND VGND VPWR VPWR _1756_ sky130_fd_sc_hd__xnor2_1
X_2818_ _0770_ _0740_ VGND VGND VPWR VPWR _0771_ sky130_fd_sc_hd__nand2b_1
X_3798_ _1671_ _1686_ VGND VGND VPWR VPWR _1687_ sky130_fd_sc_hd__or2_1
X_2749_ net128 net165 _0668_ VGND VGND VPWR VPWR _0702_ sky130_fd_sc_hd__a21oi_1
XFILLER_11_69 VGND VGND VPWR VPWR sky130_fd_sc_hd__fill_2
XFILLER_78_309 VPWR VGND VPWR VGND sky130_ef_sc_hd__decap_12
X_4419_ clknet_leaf_3_clk _0384_ _0143_ VGND VGND VPWR VPWR systolic_unit_0.U_00.acc_0\[15\]
+ sky130_fd_sc_hd__dfrtp_1
XPHY_EDGE_ROW_21_Left_115 VGND VGND VPWR VPWR sky130_fd_sc_hd__decap_3
XFILLER_46_239 VGND VGND VPWR VPWR sky130_fd_sc_hd__decap_3
XTAP_TAPCELL_ROW_57_746 VGND VPWR sky130_fd_sc_hd__tapvpwrvgnd_1
XFILLER_27_475 VPWR VGND VPWR VGND sky130_ef_sc_hd__decap_12
XFILLER_61_209 VPWR VGND VPWR VGND sky130_ef_sc_hd__decap_12
XPHY_EDGE_ROW_30_Left_124 VGND VGND VPWR VPWR sky130_fd_sc_hd__decap_3
XTAP_TAPCELL_ROW_12_315 VGND VPWR sky130_fd_sc_hd__tapvpwrvgnd_1
Xinput19 D_b_00[2] VGND VGND VPWR VPWR net19 sky130_fd_sc_hd__clkbuf_1
XFILLER_6_357 VGND VGND VPWR VPWR sky130_fd_sc_hd__decap_6
XTAP_TAPCELL_ROW_20_392 VGND VPWR sky130_fd_sc_hd__tapvpwrvgnd_1
XFILLER_77_331 VGND VGND VPWR VPWR sky130_fd_sc_hd__fill_2
XFILLER_77_51 VGND VGND VPWR VPWR sky130_fd_sc_hd__decap_4
XFILLER_77_353 VPWR VGND VPWR VGND sky130_ef_sc_hd__decap_12
XFILLER_92_389 VPWR VGND VPWR VGND sky130_ef_sc_hd__decap_12
XFILLER_80_518 VPWR VGND VPWR VGND sky130_ef_sc_hd__decap_12
XFILLER_33_412 VGND VGND VPWR VPWR sky130_fd_sc_hd__fill_1
XFILLER_52_209 VGND VGND VPWR VPWR sky130_fd_sc_hd__fill_1
XTAP_TAPCELL_ROW_28_470 VGND VPWR sky130_fd_sc_hd__tapvpwrvgnd_1
XFILLER_33_445 VGND VGND VPWR VPWR sky130_fd_sc_hd__decap_3
XFILLER_60_253 VPWR VGND VPWR VGND sky130_ef_sc_hd__decap_12
XFILLER_20_139 VGND VGND VPWR VPWR sky130_fd_sc_hd__fill_1
XFILLER_9_151 VGND VGND VPWR VPWR sky130_fd_sc_hd__decap_8
X_3721_ _1574_ _1609_ VGND VGND VPWR VPWR _1610_ sky130_fd_sc_hd__or2_1
X_3652_ net189 net191 _1539_ VGND VGND VPWR VPWR _1541_ sky130_fd_sc_hd__and3_1
X_3583_ net184 net193 VGND VGND VPWR VPWR _1472_ sky130_fd_sc_hd__and2_1
X_2603_ _0522_ _0579_ VGND VGND VPWR VPWR _0580_ sky130_fd_sc_hd__xnor2_1
X_2534_ _0500_ _0516_ _0487_ _0499_ VGND VGND VPWR VPWR _0519_ sky130_fd_sc_hd__a211oi_2
X_2465_ _0429_ _0435_ _0434_ VGND VGND VPWR VPWR _0450_ sky130_fd_sc_hd__o21a_1
X_4204_ net222 VGND VGND VPWR VPWR _0185_ sky130_fd_sc_hd__inv_2
X_2396_ net275 net259 _2087_ _2085_ VGND VGND VPWR VPWR _2095_ sky130_fd_sc_hd__a31o_1
XFILLER_3_81 VPWR VGND VPWR VGND sky130_ef_sc_hd__decap_12
X_4135_ net232 VGND VGND VPWR VPWR _0116_ sky130_fd_sc_hd__inv_2
XFILLER_83_356 VGND VGND VPWR VPWR sky130_fd_sc_hd__decap_8
X_4066_ net229 VGND VGND VPWR VPWR _0047_ sky130_fd_sc_hd__inv_2
XFILLER_83_389 VGND VGND VPWR VPWR sky130_fd_sc_hd__decap_3
XFILLER_71_529 VPWR VGND VPWR VGND sky130_ef_sc_hd__decap_12
XTAP_TAPCELL_ROW_54_716 VGND VPWR sky130_fd_sc_hd__tapvpwrvgnd_1
X_3017_ net424 net85 _0963_ net140 VGND VGND VPWR VPWR _0346_ sky130_fd_sc_hd__a22o_1
XFILLER_51_220 VGND VGND VPWR VPWR sky130_fd_sc_hd__decap_4
XFILLER_51_242 VGND VGND VPWR VPWR sky130_fd_sc_hd__decap_8
XTAP_TAPCELL_ROW_62_793 VGND VPWR sky130_fd_sc_hd__tapvpwrvgnd_1
X_3919_ _1761_ _1762_ _1764_ VGND VGND VPWR VPWR _1802_ sky130_fd_sc_hd__o21a_1
XFILLER_78_106 VGND VGND VPWR VPWR sky130_fd_sc_hd__decap_3
Xfanout130 systolic_unit_0.U_01.in_b\[0\] VGND VGND VPWR VPWR net130 sky130_fd_sc_hd__clkbuf_2
XFILLER_93_109 VGND VGND VPWR VPWR sky130_fd_sc_hd__decap_3
Xfanout174 systolic_unit_0.U_00.out_a\[2\] VGND VGND VPWR VPWR net174 sky130_fd_sc_hd__buf_1
Xfanout152 systolic_unit_0.U_00.out_b\[7\] VGND VGND VPWR VPWR net152 sky130_fd_sc_hd__buf_2
Xfanout163 net164 VGND VGND VPWR VPWR net163 sky130_fd_sc_hd__buf_2
Xfanout141 net142 VGND VGND VPWR VPWR net141 sky130_fd_sc_hd__buf_2
XFILLER_74_301 VGND VGND VPWR VPWR sky130_fd_sc_hd__decap_6
Xfanout196 systolic_unit_0.U_10.out_a\[4\] VGND VGND VPWR VPWR net196 sky130_fd_sc_hd__buf_2
Xfanout185 net186 VGND VGND VPWR VPWR net185 sky130_fd_sc_hd__buf_2
XFILLER_74_345 VPWR VGND VPWR VGND sky130_ef_sc_hd__decap_12
XFILLER_74_389 VPWR VGND VPWR VGND sky130_ef_sc_hd__decap_12
XFILLER_34_209 VGND VGND VPWR VPWR sky130_fd_sc_hd__decap_4
XPHY_EDGE_ROW_69_Right_69 VGND VGND VPWR VPWR sky130_fd_sc_hd__decap_3
XTAP_TAPCELL_ROW_25_440 VGND VPWR sky130_fd_sc_hd__tapvpwrvgnd_1
XFILLER_42_242 VGND VGND VPWR VPWR sky130_fd_sc_hd__fill_1
XFILLER_42_253 VGND VGND VPWR VPWR sky130_fd_sc_hd__decap_3
XFILLER_8_15 VPWR VGND VPWR VGND sky130_ef_sc_hd__decap_12
XFILLER_30_415 VGND VGND VPWR VPWR sky130_fd_sc_hd__decap_4
XFILLER_63_86 VPWR VGND VPWR VGND sky130_ef_sc_hd__decap_12
XFILLER_6_110 VPWR VGND VPWR VGND sky130_ef_sc_hd__decap_12
XFILLER_6_176 VPWR VGND VPWR VGND sky130_ef_sc_hd__decap_12
XPHY_EDGE_ROW_78_Right_78 VGND VGND VPWR VPWR sky130_fd_sc_hd__decap_3
XFILLER_88_83 VGND VGND VPWR VPWR sky130_fd_sc_hd__fill_1
X_2250_ _1947_ _1948_ VGND VGND VPWR VPWR _1949_ sky130_fd_sc_hd__nand2_1
XFILLER_2_360 VGND VGND VPWR VPWR sky130_fd_sc_hd__decap_4
XFILLER_33_6 VGND VGND VPWR VPWR sky130_fd_sc_hd__decap_3
XFILLER_84_109 VPWR VGND VPWR VGND sky130_ef_sc_hd__decap_12
X_2181_ net348 _1890_ net91 VGND VGND VPWR VPWR _0395_ sky130_fd_sc_hd__mux2_1
XFILLER_65_301 VPWR VGND VPWR VGND sky130_ef_sc_hd__decap_12
XFILLER_65_334 VGND VGND VPWR VPWR sky130_fd_sc_hd__fill_2
XFILLER_92_153 VPWR VGND VPWR VGND sky130_ef_sc_hd__decap_12
XFILLER_53_529 VGND VGND VPWR VPWR sky130_fd_sc_hd__decap_4
XFILLER_92_197 VPWR VGND VPWR VGND sky130_ef_sc_hd__decap_12
XPHY_EDGE_ROW_87_Right_87 VGND VGND VPWR VPWR sky130_fd_sc_hd__decap_3
XFILLER_80_326 VPWR VGND VPWR VGND sky130_ef_sc_hd__decap_12
XFILLER_21_437 VGND VGND VPWR VPWR sky130_fd_sc_hd__decap_8
X_3704_ net202 net200 net181 net180 VGND VGND VPWR VPWR _1593_ sky130_fd_sc_hd__and4_1
XTAP_TAPCELL_ROW_31_498 VGND VPWR sky130_fd_sc_hd__tapvpwrvgnd_1
X_3635_ _1501_ _1512_ _1523_ VGND VGND VPWR VPWR _1524_ sky130_fd_sc_hd__a21o_1
X_3566_ _1450_ _1451_ _1453_ VGND VGND VPWR VPWR _1455_ sky130_fd_sc_hd__or3_1
X_3497_ net134 _1352_ VGND VGND VPWR VPWR _1402_ sky130_fd_sc_hd__or2_1
X_2517_ _0475_ _0495_ _0494_ VGND VGND VPWR VPWR _0502_ sky130_fd_sc_hd__o21a_1
XFILLER_88_437 VPWR VGND VPWR VGND sky130_ef_sc_hd__decap_12
X_2448_ _0424_ _0431_ VGND VGND VPWR VPWR _0433_ sky130_fd_sc_hd__or2_1
X_2379_ net266 net254 net265 net262 VGND VGND VPWR VPWR _2078_ sky130_fd_sc_hd__nand4_1
XTAP_TAPCELL_ROW_67_841 VGND VPWR sky130_fd_sc_hd__tapvpwrvgnd_1
X_4118_ net249 VGND VGND VPWR VPWR _0099_ sky130_fd_sc_hd__inv_2
XFILLER_16_209 VPWR VGND VPWR VGND sky130_ef_sc_hd__decap_12
XTAP_TAPCELL_ROW_39_576 VGND VPWR sky130_fd_sc_hd__tapvpwrvgnd_1
X_4049_ net251 VGND VGND VPWR VPWR _0030_ sky130_fd_sc_hd__inv_2
XFILLER_71_337 VPWR VGND VPWR VGND sky130_ef_sc_hd__decap_12
XFILLER_24_253 VGND VGND VPWR VPWR sky130_fd_sc_hd__fill_1
XFILLER_8_419 VGND VGND VPWR VPWR sky130_fd_sc_hd__fill_1
XTAP_TAPCELL_ROW_22_410 VGND VPWR sky130_fd_sc_hd__tapvpwrvgnd_1
XFILLER_3_113 VPWR VGND VPWR VGND sky130_ef_sc_hd__decap_12
XFILLER_74_164 VGND VGND VPWR VPWR sky130_fd_sc_hd__decap_6
XFILLER_74_41 VPWR VGND VPWR VGND sky130_ef_sc_hd__decap_12
XFILLER_74_197 VPWR VGND VPWR VGND sky130_ef_sc_hd__decap_12
XFILLER_74_85 VPWR VGND VPWR VGND sky130_ef_sc_hd__decap_12
XFILLER_74_74 VGND VGND VPWR VPWR sky130_fd_sc_hd__decap_8
XTAP_TAPCELL_ROW_73_899 VGND VPWR sky130_fd_sc_hd__tapvpwrvgnd_1
XFILLER_7_441 VGND VGND VPWR VPWR sky130_fd_sc_hd__decap_6
XFILLER_7_485 VPWR VGND VPWR VGND sky130_ef_sc_hd__decap_12
X_3420_ _1061_ _1089_ VGND VGND VPWR VPWR _1341_ sky130_fd_sc_hd__xnor2_1
X_3351_ _1270_ _1267_ _1271_ VGND VGND VPWR VPWR _1272_ sky130_fd_sc_hd__nand3_4
X_2302_ net220 net258 _1987_ _1988_ VGND VGND VPWR VPWR _2001_ sky130_fd_sc_hd__a22o_1
X_3282_ net161 net107 net105 net163 VGND VGND VPWR VPWR _1203_ sky130_fd_sc_hd__a22o_1
X_2233_ _1908_ _1909_ _1910_ VGND VGND VPWR VPWR _1932_ sky130_fd_sc_hd__a21oi_1
X_2164_ systolic_unit_0.out_acc_0_r1\[2\] systolic_unit_0.out_acc_1_r1\[2\] net151
+ VGND VGND VPWR VPWR _1882_ sky130_fd_sc_hd__mux2_1
XFILLER_65_131 VGND VGND VPWR VPWR sky130_fd_sc_hd__fill_2
XFILLER_93_473 VGND VGND VPWR VPWR sky130_fd_sc_hd__decap_3
XTAP_TAPCELL_ROW_64_811 VGND VPWR sky130_fd_sc_hd__tapvpwrvgnd_1
XFILLER_53_337 VGND VGND VPWR VPWR sky130_fd_sc_hd__decap_8
XFILLER_80_145 VGND VGND VPWR VPWR sky130_fd_sc_hd__decap_8
XTAP_TAPCELL_ROW_36_546 VGND VPWR sky130_fd_sc_hd__tapvpwrvgnd_1
XFILLER_21_201 VGND VGND VPWR VPWR sky130_fd_sc_hd__fill_2
XFILLER_21_223 VGND VGND VPWR VPWR sky130_fd_sc_hd__fill_1
X_2997_ _0946_ _0949_ VGND VGND VPWR VPWR _0950_ sky130_fd_sc_hd__xnor2_1
X_3618_ net184 systolic_unit_0.U_10.out_a\[6\] net191 net186 VGND VGND VPWR VPWR _1507_
+ sky130_fd_sc_hd__a22oi_1
X_3549_ systolic_unit_0.U_11.acc_1\[13\] systolic_unit_0.U_11.acc_0\[13\] net148 VGND
+ VGND VPWR VPWR _1438_ sky130_fd_sc_hd__mux2_1
XFILLER_88_245 VGND VGND VPWR VPWR sky130_fd_sc_hd__decap_6
XFILLER_76_418 VGND VGND VPWR VPWR sky130_fd_sc_hd__fill_2
XFILLER_29_334 VGND VGND VPWR VPWR sky130_fd_sc_hd__fill_2
XFILLER_17_529 VPWR VGND VPWR VGND sky130_ef_sc_hd__decap_12
XFILLER_29_367 VPWR VGND VPWR VGND sky130_ef_sc_hd__decap_12
XFILLER_56_197 VPWR VGND VPWR VGND sky130_ef_sc_hd__decap_12
XFILLER_71_189 VPWR VGND VPWR VGND sky130_ef_sc_hd__decap_12
XFILLER_40_510 VGND VGND VPWR VPWR sky130_fd_sc_hd__fill_1
XTAP_TAPCELL_ROW_70_869 VGND VPWR sky130_fd_sc_hd__tapvpwrvgnd_1
XFILLER_60_10 VGND VGND VPWR VPWR sky130_fd_sc_hd__fill_1
XFILLER_8_238 VGND VGND VPWR VPWR sky130_fd_sc_hd__decap_8
XFILLER_5_27 VPWR VGND VPWR VGND sky130_ef_sc_hd__decap_12
XFILLER_4_433 VPWR VGND VPWR VGND sky130_ef_sc_hd__decap_12
XFILLER_69_30 VPWR VGND VPWR VGND sky130_ef_sc_hd__decap_12
XFILLER_4_477 VPWR VGND VPWR VGND sky130_ef_sc_hd__decap_12
XFILLER_79_223 VGND VGND VPWR VPWR sky130_fd_sc_hd__fill_1
XTAP_TAPCELL_ROW_7_271 VGND VPWR sky130_fd_sc_hd__tapvpwrvgnd_1
XFILLER_85_51 VGND VGND VPWR VPWR sky130_fd_sc_hd__decap_4
XTAP_TAPCELL_ROW_78_947 VGND VPWR sky130_fd_sc_hd__tapvpwrvgnd_1
Xclkbuf_2_3__f_clk clknet_0_clk VGND VGND VPWR VPWR clknet_2_3__leaf_clk sky130_fd_sc_hd__clkbuf_16
XFILLER_62_134 VGND VGND VPWR VPWR sky130_fd_sc_hd__decap_6
X_2920_ _0849_ _0850_ VGND VGND VPWR VPWR _0873_ sky130_fd_sc_hd__xnor2_1
XTAP_TAPCELL_ROW_33_516 VGND VPWR sky130_fd_sc_hd__tapvpwrvgnd_1
XFILLER_50_307 VGND VGND VPWR VPWR sky130_fd_sc_hd__fill_1
X_2851_ _0797_ _0803_ VGND VGND VPWR VPWR _0804_ sky130_fd_sc_hd__xnor2_1
X_2782_ _0733_ _0734_ VGND VGND VPWR VPWR _0735_ sky130_fd_sc_hd__and2_1
XTAP_TAPCELL_ROW_41_593 VGND VPWR sky130_fd_sc_hd__tapvpwrvgnd_1
X_4452_ clknet_leaf_30_clk _0401_ _0176_ VGND VGND VPWR VPWR net39 sky130_fd_sc_hd__dfrtp_1
X_3403_ _1316_ _1323_ _1315_ VGND VGND VPWR VPWR _1324_ sky130_fd_sc_hd__a21o_1
X_4383_ clknet_leaf_4_clk _0356_ _0107_ VGND VGND VPWR VPWR systolic_unit_0.U_00.acc_1\[3\]
+ sky130_fd_sc_hd__dfrtp_1
X_3334_ _1215_ _1217_ _1252_ _1253_ VGND VGND VPWR VPWR _1255_ sky130_fd_sc_hd__a211o_1
X_3265_ _1182_ _1184_ VGND VGND VPWR VPWR _1186_ sky130_fd_sc_hd__xnor2_1
XFILLER_85_237 VPWR VGND VPWR VGND sky130_ef_sc_hd__decap_12
X_2216_ _1903_ _1914_ VGND VGND VPWR VPWR _1915_ sky130_fd_sc_hd__nor2_1
X_3196_ _1098_ _1099_ VGND VGND VPWR VPWR _1117_ sky130_fd_sc_hd__nand2_1
XFILLER_93_281 VGND VGND VPWR VPWR sky130_fd_sc_hd__fill_2
X_2147_ net345 _1873_ net90 VGND VGND VPWR VPWR _0412_ sky130_fd_sc_hd__mux2_1
XFILLER_38_197 VGND VGND VPWR VPWR sky130_fd_sc_hd__decap_3
XTAP_TAPCELL_ROW_49_671 VGND VPWR sky130_fd_sc_hd__tapvpwrvgnd_1
XFILLER_81_465 VGND VGND VPWR VPWR sky130_fd_sc_hd__fill_2
XFILLER_81_498 VGND VGND VPWR VPWR sky130_fd_sc_hd__decap_6
XFILLER_22_510 VPWR VGND VPWR VGND sky130_ef_sc_hd__decap_12
XFILLER_41_329 VGND VGND VPWR VPWR sky130_fd_sc_hd__decap_4
XFILLER_53_167 VGND VGND VPWR VPWR sky130_fd_sc_hd__fill_1
XFILLER_14_69 VPWR VGND VPWR VGND sky130_ef_sc_hd__decap_12
XFILLER_1_447 VGND VGND VPWR VPWR sky130_fd_sc_hd__fill_1
XFILLER_39_66 VGND VGND VPWR VPWR sky130_fd_sc_hd__fill_2
XTAP_TAPCELL_ROW_4_241 VGND VPWR sky130_fd_sc_hd__tapvpwrvgnd_1
XTAP_TAPCELL_ROW_75_917 VGND VPWR sky130_fd_sc_hd__tapvpwrvgnd_1
XFILLER_72_421 VPWR VGND VPWR VGND sky130_ef_sc_hd__decap_12
XFILLER_17_337 VPWR VGND VPWR VGND sky130_ef_sc_hd__decap_12
XFILLER_55_21 VPWR VGND VPWR VGND sky130_ef_sc_hd__decap_12
XTAP_TAPCELL_ROW_83_994 VGND VPWR sky130_fd_sc_hd__tapvpwrvgnd_1
XFILLER_32_329 VGND VGND VPWR VPWR sky130_fd_sc_hd__fill_2
XFILLER_44_167 VGND VGND VPWR VPWR sky130_fd_sc_hd__fill_1
XFILLER_71_53 VGND VGND VPWR VPWR sky130_fd_sc_hd__decap_3
XFILLER_9_503 VGND VGND VPWR VPWR sky130_fd_sc_hd__fill_1
XFILLER_40_362 VGND VGND VPWR VPWR sky130_fd_sc_hd__fill_2
XTAP_TAPCELL_ROW_10_298 VGND VPWR sky130_fd_sc_hd__tapvpwrvgnd_1
XFILLER_67_237 VGND VGND VPWR VPWR sky130_fd_sc_hd__decap_6
XFILLER_67_248 VPWR VGND VPWR VGND sky130_ef_sc_hd__decap_12
X_3050_ net95 _0967_ net77 net387 VGND VGND VPWR VPWR _0326_ sky130_fd_sc_hd__a22o_1
XTAP_TAPCELL_ROW_85_1013 VGND VPWR sky130_fd_sc_hd__tapvpwrvgnd_1
XFILLER_35_134 VGND VGND VPWR VPWR sky130_fd_sc_hd__decap_6
XFILLER_35_156 VGND VGND VPWR VPWR sky130_fd_sc_hd__fill_1
XTAP_TAPCELL_ROW_46_641 VGND VPWR sky130_fd_sc_hd__tapvpwrvgnd_1
XFILLER_90_251 VGND VGND VPWR VPWR sky130_fd_sc_hd__fill_1
XTAP_TAPCELL_ROW_18_376 VGND VPWR sky130_fd_sc_hd__tapvpwrvgnd_1
XFILLER_35_167 VGND VGND VPWR VPWR sky130_fd_sc_hd__fill_1
XFILLER_35_189 VGND VGND VPWR VPWR sky130_fd_sc_hd__decap_6
X_3952_ _1746_ _1825_ net98 VGND VGND VPWR VPWR _1826_ sky130_fd_sc_hd__a21o_1
X_2903_ _0854_ _0855_ VGND VGND VPWR VPWR _0856_ sky130_fd_sc_hd__nor2_1
X_3883_ _1533_ _1572_ _1610_ VGND VGND VPWR VPWR _1772_ sky130_fd_sc_hd__o21a_1
X_2834_ _0780_ _0786_ VGND VGND VPWR VPWR _0787_ sky130_fd_sc_hd__nand2_1
X_2765_ net174 net172 net120 net119 VGND VGND VPWR VPWR _0718_ sky130_fd_sc_hd__and4_1
X_4504_ clknet_leaf_11_clk net210 _0228_ VGND VGND VPWR VPWR systolic_unit_0.U_01.switch
+ sky130_fd_sc_hd__dfrtp_1
X_2696_ _0647_ _0648_ VGND VGND VPWR VPWR _0649_ sky130_fd_sc_hd__nor2_1
X_4435_ clknet_leaf_16_clk _0392_ _0159_ VGND VGND VPWR VPWR net54 sky130_fd_sc_hd__dfrtp_1
X_4366_ clknet_leaf_10_clk _0339_ _0090_ VGND VGND VPWR VPWR systolic_unit_0.U_01.acc_0\[2\]
+ sky130_fd_sc_hd__dfrtp_1
XFILLER_86_513 VPWR VGND VPWR VGND sky130_ef_sc_hd__decap_12
X_3317_ _1205_ _1236_ _1235_ VGND VGND VPWR VPWR _1238_ sky130_fd_sc_hd__o21ai_1
X_4297_ clknet_leaf_19_clk _0278_ _0021_ VGND VGND VPWR VPWR systolic_unit_0.U_11.acc_0\[5\]
+ sky130_fd_sc_hd__dfrtp_1
XFILLER_58_226 VGND VGND VPWR VPWR sky130_fd_sc_hd__fill_1
XFILLER_58_248 VGND VGND VPWR VPWR sky130_fd_sc_hd__fill_1
X_3248_ net158 net109 net156 net111 VGND VGND VPWR VPWR _1169_ sky130_fd_sc_hd__a22o_1
X_3179_ _1098_ _1099_ VGND VGND VPWR VPWR _1100_ sky130_fd_sc_hd__or2_1
XTAP_TAPCELL_ROW_1_211 VGND VPWR sky130_fd_sc_hd__tapvpwrvgnd_1
XFILLER_39_495 VGND VGND VPWR VPWR sky130_fd_sc_hd__decap_8
XFILLER_54_421 VGND VGND VPWR VPWR sky130_fd_sc_hd__fill_1
XFILLER_81_273 VGND VGND VPWR VPWR sky130_fd_sc_hd__decap_4
XFILLER_14_307 VGND VGND VPWR VPWR sky130_fd_sc_hd__fill_1
XFILLER_25_57 VPWR VGND VPWR VGND sky130_ef_sc_hd__decap_12
XTAP_TAPCELL_ROW_80_964 VGND VPWR sky130_fd_sc_hd__tapvpwrvgnd_1
XFILLER_10_513 VPWR VGND VPWR VGND sky130_ef_sc_hd__decap_12
XTAP_TAPCELL_ROW_52_699 VGND VPWR sky130_fd_sc_hd__tapvpwrvgnd_1
XFILLER_9_3 VPWR VGND VPWR VGND sky130_ef_sc_hd__decap_12
XFILLER_1_288 VGND VGND VPWR VPWR sky130_fd_sc_hd__decap_8
XFILLER_45_410 VGND VGND VPWR VPWR sky130_fd_sc_hd__decap_3
XFILLER_82_41 VPWR VGND VPWR VGND sky130_ef_sc_hd__decap_12
XFILLER_32_126 VPWR VGND VPWR VGND sky130_ef_sc_hd__decap_12
XTAP_TAPCELL_ROW_43_611 VGND VPWR sky130_fd_sc_hd__tapvpwrvgnd_1
XFILLER_82_85 VPWR VGND VPWR VGND sky130_ef_sc_hd__decap_12
XTAP_TAPCELL_ROW_15_346 VGND VPWR sky130_fd_sc_hd__tapvpwrvgnd_1
XFILLER_13_373 VPWR VGND VPWR VGND sky130_ef_sc_hd__decap_12
X_2550_ _0531_ _0534_ VGND VGND VPWR VPWR _0535_ sky130_fd_sc_hd__nand2_1
X_2481_ _0465_ _0449_ VGND VGND VPWR VPWR _0466_ sky130_fd_sc_hd__nand2b_1
X_4220_ net227 VGND VGND VPWR VPWR _0201_ sky130_fd_sc_hd__inv_2
X_4151_ net234 VGND VGND VPWR VPWR _0132_ sky130_fd_sc_hd__inv_2
XFILLER_83_505 VPWR VGND VPWR VGND sky130_ef_sc_hd__decap_12
X_3102_ _1021_ _1022_ VGND VGND VPWR VPWR _1023_ sky130_fd_sc_hd__and2_1
X_4082_ net230 VGND VGND VPWR VPWR _0063_ sky130_fd_sc_hd__inv_2
X_3033_ net383 net84 _0972_ net138 VGND VGND VPWR VPWR _0339_ sky130_fd_sc_hd__a22o_1
XFILLER_36_421 VPWR VGND VPWR VGND sky130_ef_sc_hd__decap_12
XFILLER_51_479 VGND VGND VPWR VPWR sky130_fd_sc_hd__decap_8
X_3935_ systolic_unit_0.U_01.acc_0\[5\] net75 net82 systolic_unit_0.U_11.acc_0\[5\]
+ VGND VGND VPWR VPWR _1814_ sky130_fd_sc_hd__a22o_1
XFILLER_31_181 VGND VGND VPWR VPWR sky130_fd_sc_hd__decap_4
X_3866_ _1737_ _1754_ VGND VGND VPWR VPWR _1755_ sky130_fd_sc_hd__or2_1
X_2817_ _0767_ _0768_ _0757_ VGND VGND VPWR VPWR _0770_ sky130_fd_sc_hd__a21oi_1
XFILLER_11_15 VGND VGND VPWR VPWR sky130_fd_sc_hd__fill_2
X_3797_ _1684_ _1685_ _1679_ VGND VGND VPWR VPWR _1686_ sky130_fd_sc_hd__a21boi_2
X_2748_ _0676_ _0678_ VGND VGND VPWR VPWR _0701_ sky130_fd_sc_hd__xnor2_1
XFILLER_11_26 VPWR VGND VPWR VGND sky130_ef_sc_hd__decap_12
X_2679_ _0611_ _0631_ VGND VGND VPWR VPWR _0632_ sky130_fd_sc_hd__xor2_1
X_4418_ clknet_leaf_5_clk _0383_ _0142_ VGND VGND VPWR VPWR systolic_unit_0.U_00.acc_0\[14\]
+ sky130_fd_sc_hd__dfrtp_1
XFILLER_59_502 VGND VGND VPWR VPWR sky130_fd_sc_hd__fill_2
XFILLER_86_321 VPWR VGND VPWR VGND sky130_ef_sc_hd__decap_12
X_4349_ clknet_leaf_12_clk _0322_ _0073_ VGND VGND VPWR VPWR systolic_unit_0.U_01.acc_1\[1\]
+ sky130_fd_sc_hd__dfrtp_1
XFILLER_86_365 VPWR VGND VPWR VGND sky130_ef_sc_hd__decap_12
XTAP_TAPCELL_ROW_57_747 VGND VPWR sky130_fd_sc_hd__tapvpwrvgnd_1
XFILLER_14_104 VPWR VGND VPWR VGND sky130_ef_sc_hd__decap_12
XFILLER_27_487 VGND VGND VPWR VPWR sky130_fd_sc_hd__decap_4
XFILLER_54_251 VGND VGND VPWR VPWR sky130_fd_sc_hd__fill_1
XFILLER_52_11 VGND VGND VPWR VPWR sky130_fd_sc_hd__fill_1
XTAP_TAPCELL_ROW_12_316 VGND VPWR sky130_fd_sc_hd__tapvpwrvgnd_1
XTAP_TAPCELL_ROW_20_393 VGND VPWR sky130_fd_sc_hd__tapvpwrvgnd_1
XFILLER_2_531 VGND VGND VPWR VPWR sky130_fd_sc_hd__fill_1
XFILLER_2_553 VGND VGND VPWR VPWR sky130_fd_sc_hd__fill_1
XFILLER_89_181 VPWR VGND VPWR VGND sky130_ef_sc_hd__decap_12
XFILLER_77_365 VGND VGND VPWR VPWR sky130_fd_sc_hd__decap_3
XFILLER_65_516 VPWR VGND VPWR VGND sky130_ef_sc_hd__decap_12
XFILLER_18_421 VGND VGND VPWR VPWR sky130_fd_sc_hd__decap_3
XTAP_TAPCELL_ROW_28_471 VGND VPWR sky130_fd_sc_hd__tapvpwrvgnd_1
XFILLER_45_273 VGND VGND VPWR VPWR sky130_fd_sc_hd__fill_2
XFILLER_33_457 VGND VGND VPWR VPWR sky130_fd_sc_hd__decap_6
XFILLER_60_265 VPWR VGND VPWR VGND sky130_ef_sc_hd__decap_12
X_3720_ _1607_ _1608_ _1606_ VGND VGND VPWR VPWR _1609_ sky130_fd_sc_hd__a21oi_1
X_3651_ net189 net191 VGND VGND VPWR VPWR _1540_ sky130_fd_sc_hd__nand2_1
XFILLER_9_196 VGND VGND VPWR VPWR sky130_fd_sc_hd__decap_8
X_3582_ systolic_unit_0.U_01.out_b\[4\] systolic_unit_0.U_10.out_a\[6\] net191 net184
+ VGND VGND VPWR VPWR _1471_ sky130_fd_sc_hd__a22o_1
X_2602_ _0466_ _0521_ VGND VGND VPWR VPWR _0579_ sky130_fd_sc_hd__nand2_1
XFILLER_61_3 VGND VGND VPWR VPWR sky130_fd_sc_hd__fill_2
X_2533_ _0487_ _0488_ VGND VGND VPWR VPWR _0518_ sky130_fd_sc_hd__nor2_1
X_2464_ _0439_ _0448_ VGND VGND VPWR VPWR _0449_ sky130_fd_sc_hd__nor2_1
X_4203_ net227 VGND VGND VPWR VPWR _0184_ sky130_fd_sc_hd__inv_2
X_2395_ _2016_ _2093_ VGND VGND VPWR VPWR _2094_ sky130_fd_sc_hd__nand2b_1
X_4134_ net225 VGND VGND VPWR VPWR _0115_ sky130_fd_sc_hd__inv_2
XFILLER_3_93 VPWR VGND VPWR VGND sky130_ef_sc_hd__decap_12
XFILLER_83_335 VGND VGND VPWR VPWR sky130_fd_sc_hd__fill_1
X_4065_ net230 VGND VGND VPWR VPWR _0046_ sky130_fd_sc_hd__inv_2
XFILLER_83_379 VGND VGND VPWR VPWR sky130_fd_sc_hd__fill_1
X_3016_ _0813_ _0962_ VGND VGND VPWR VPWR _0963_ sky130_fd_sc_hd__xnor2_1
XTAP_TAPCELL_ROW_54_717 VGND VPWR sky130_fd_sc_hd__tapvpwrvgnd_1
XFILLER_51_210 VGND VGND VPWR VPWR sky130_fd_sc_hd__fill_2
XTAP_TAPCELL_ROW_62_794 VGND VPWR sky130_fd_sc_hd__tapvpwrvgnd_1
Xclkbuf_leaf_31_clk clknet_2_0__leaf_clk VGND VGND VPWR VPWR clknet_leaf_31_clk sky130_fd_sc_hd__clkbuf_8
X_3918_ net150 _1800_ _1801_ VGND VGND VPWR VPWR _0283_ sky130_fd_sc_hd__a21o_1
X_3849_ _1735_ _1736_ VGND VGND VPWR VPWR _1738_ sky130_fd_sc_hd__xnor2_1
Xfanout120 systolic_unit_0.U_01.in_b\[5\] VGND VGND VPWR VPWR net120 sky130_fd_sc_hd__buf_2
Xfanout131 systolic_unit_0.U_01.in_b\[0\] VGND VGND VPWR VPWR net131 sky130_fd_sc_hd__clkbuf_2
Xfanout153 systolic_unit_0.U_00.out_b\[7\] VGND VGND VPWR VPWR net153 sky130_fd_sc_hd__buf_1
Xfanout164 systolic_unit_0.U_00.out_b\[0\] VGND VGND VPWR VPWR net164 sky130_fd_sc_hd__buf_2
Xfanout142 systolic_unit_0.U_01.switch VGND VGND VPWR VPWR net142 sky130_fd_sc_hd__buf_8
XFILLER_47_505 VGND VGND VPWR VPWR sky130_fd_sc_hd__fill_2
XFILLER_59_332 VGND VGND VPWR VPWR sky130_fd_sc_hd__fill_1
XFILLER_59_354 VPWR VGND VPWR VGND sky130_ef_sc_hd__decap_12
Xfanout197 systolic_unit_0.U_10.out_a\[4\] VGND VGND VPWR VPWR net197 sky130_fd_sc_hd__clkbuf_1
XFILLER_47_55 VGND VGND VPWR VPWR sky130_fd_sc_hd__fill_1
Xfanout186 systolic_unit_0.U_01.out_b\[2\] VGND VGND VPWR VPWR net186 sky130_fd_sc_hd__buf_2
Xfanout175 systolic_unit_0.U_00.out_a\[1\] VGND VGND VPWR VPWR net175 sky130_fd_sc_hd__buf_2
XFILLER_86_195 VGND VGND VPWR VPWR sky130_fd_sc_hd__fill_1
XFILLER_74_357 VGND VGND VPWR VPWR sky130_fd_sc_hd__decap_3
XFILLER_47_66 VGND VGND VPWR VPWR sky130_fd_sc_hd__decap_4
XFILLER_47_77 VPWR VGND VPWR VGND sky130_ef_sc_hd__decap_12
XFILLER_47_99 VGND VGND VPWR VPWR sky130_fd_sc_hd__decap_4
XFILLER_27_273 VGND VGND VPWR VPWR sky130_fd_sc_hd__decap_6
XFILLER_42_221 VGND VGND VPWR VPWR sky130_fd_sc_hd__fill_1
XFILLER_63_21 VPWR VGND VPWR VGND sky130_ef_sc_hd__decap_12
XTAP_TAPCELL_ROW_25_441 VGND VPWR sky130_fd_sc_hd__tapvpwrvgnd_1
XFILLER_63_54 VGND VGND VPWR VPWR sky130_fd_sc_hd__fill_2
XFILLER_63_98 VGND VGND VPWR VPWR sky130_fd_sc_hd__decap_3
XFILLER_8_27 VGND VGND VPWR VPWR sky130_fd_sc_hd__fill_1
Xclkbuf_leaf_22_clk clknet_2_3__leaf_clk VGND VGND VPWR VPWR clknet_leaf_22_clk sky130_fd_sc_hd__clkbuf_8
XFILLER_6_122 VGND VGND VPWR VPWR sky130_fd_sc_hd__decap_8
XFILLER_6_188 VGND VGND VPWR VPWR sky130_fd_sc_hd__decap_8
X_2180_ systolic_unit_0.U_11.acc_0\[10\] systolic_unit_0.U_11.acc_1\[10\] net150 VGND
+ VGND VPWR VPWR _1890_ sky130_fd_sc_hd__mux2_1
XFILLER_65_313 VPWR VGND VPWR VGND sky130_ef_sc_hd__decap_12
XFILLER_92_121 VPWR VGND VPWR VGND sky130_ef_sc_hd__decap_12
XFILLER_92_165 VPWR VGND VPWR VGND sky130_ef_sc_hd__decap_12
XFILLER_80_338 VGND VGND VPWR VPWR sky130_fd_sc_hd__decap_3
Xclkbuf_leaf_13_clk clknet_2_2__leaf_clk VGND VGND VPWR VPWR clknet_leaf_13_clk sky130_fd_sc_hd__clkbuf_8
XFILLER_21_449 VGND VGND VPWR VPWR sky130_fd_sc_hd__decap_6
XFILLER_33_298 VGND VGND VPWR VPWR sky130_fd_sc_hd__fill_1
X_3703_ _1576_ _1591_ VGND VGND VPWR VPWR _1592_ sky130_fd_sc_hd__or2_1
X_3634_ _1521_ _1522_ VGND VGND VPWR VPWR _1523_ sky130_fd_sc_hd__and2_1
XTAP_TAPCELL_ROW_31_499 VGND VPWR sky130_fd_sc_hd__tapvpwrvgnd_1
X_3565_ _1451_ _1453_ _1450_ VGND VGND VPWR VPWR _1454_ sky130_fd_sc_hd__o21ai_1
XFILLER_0_309 VGND VGND VPWR VPWR sky130_fd_sc_hd__fill_2
X_3496_ net316 _1356_ _1400_ _1401_ VGND VGND VPWR VPWR _0305_ sky130_fd_sc_hd__a22o_1
X_2516_ _0499_ _0500_ VGND VGND VPWR VPWR _0501_ sky130_fd_sc_hd__nand2b_1
XFILLER_88_449 VGND VGND VPWR VPWR sky130_fd_sc_hd__decap_8
X_2447_ _0424_ _0431_ VGND VGND VPWR VPWR _0432_ sky130_fd_sc_hd__nand2_1
XFILLER_68_173 VGND VGND VPWR VPWR sky130_fd_sc_hd__fill_1
X_2378_ _2039_ _2041_ _2040_ VGND VGND VPWR VPWR _2077_ sky130_fd_sc_hd__o21ai_1
XFILLER_68_195 VGND VGND VPWR VPWR sky130_fd_sc_hd__fill_1
XTAP_TAPCELL_ROW_67_842 VGND VPWR sky130_fd_sc_hd__tapvpwrvgnd_1
X_4117_ net251 VGND VGND VPWR VPWR _0098_ sky130_fd_sc_hd__inv_2
XFILLER_17_25 VGND VGND VPWR VPWR sky130_fd_sc_hd__decap_3
X_4048_ net250 VGND VGND VPWR VPWR _0029_ sky130_fd_sc_hd__inv_2
XFILLER_71_349 VGND VGND VPWR VPWR sky130_fd_sc_hd__decap_3
XTAP_TAPCELL_ROW_22_411 VGND VPWR sky130_fd_sc_hd__tapvpwrvgnd_1
XFILLER_3_125 VGND VGND VPWR VPWR sky130_fd_sc_hd__fill_1
XFILLER_79_405 VPWR VGND VPWR VGND sky130_ef_sc_hd__decap_12
XFILLER_3_147 VGND VGND VPWR VPWR sky130_fd_sc_hd__decap_6
XFILLER_3_169 VGND VGND VPWR VPWR sky130_fd_sc_hd__decap_8
XFILLER_79_449 VPWR VGND VPWR VGND sky130_ef_sc_hd__decap_12
XFILLER_87_471 VPWR VGND VPWR VGND sky130_ef_sc_hd__decap_12
XFILLER_47_335 VGND VGND VPWR VPWR sky130_fd_sc_hd__fill_1
XFILLER_35_508 VPWR VGND VPWR VGND sky130_ef_sc_hd__decap_12
XFILLER_74_176 VPWR VGND VPWR VGND sky130_ef_sc_hd__decap_12
XFILLER_74_53 VPWR VGND VPWR VGND sky130_ef_sc_hd__decap_12
XFILLER_74_97 VGND VGND VPWR VPWR sky130_fd_sc_hd__decap_8
XFILLER_30_213 VGND VGND VPWR VPWR sky130_fd_sc_hd__decap_3
XFILLER_90_41 VPWR VGND VPWR VGND sky130_ef_sc_hd__decap_12
XFILLER_90_85 VPWR VGND VPWR VGND sky130_ef_sc_hd__decap_12
XFILLER_23_90 VGND VGND VPWR VPWR sky130_fd_sc_hd__decap_4
XFILLER_7_497 VGND VGND VPWR VPWR sky130_fd_sc_hd__decap_6
X_3350_ _1207_ _1268_ _1269_ _1229_ VGND VGND VPWR VPWR _1271_ sky130_fd_sc_hd__o22ai_1
X_2301_ _1992_ _1993_ VGND VGND VPWR VPWR _2000_ sky130_fd_sc_hd__xnor2_1
X_3281_ net163 net161 net107 net105 VGND VGND VPWR VPWR _1202_ sky130_fd_sc_hd__nand4_1
X_2232_ _1929_ _1930_ VGND VGND VPWR VPWR _1931_ sky130_fd_sc_hd__or2_1
XFILLER_24_3 VPWR VGND VPWR VGND sky130_ef_sc_hd__decap_12
Xclkbuf_leaf_2_clk clknet_2_0__leaf_clk VGND VGND VPWR VPWR clknet_leaf_2_clk sky130_fd_sc_hd__clkbuf_8
XTAP_TAPCELL_ROW_88_1033 VGND VPWR sky130_fd_sc_hd__tapvpwrvgnd_1
X_2163_ net355 _1881_ net93 VGND VGND VPWR VPWR _0404_ sky130_fd_sc_hd__mux2_1
XFILLER_38_324 VPWR VGND VPWR VGND sky130_ef_sc_hd__decap_12
XFILLER_65_121 VGND VGND VPWR VPWR sky130_fd_sc_hd__decap_3
XFILLER_65_143 VGND VGND VPWR VPWR sky130_fd_sc_hd__decap_3
XTAP_TAPCELL_ROW_64_812 VGND VPWR sky130_fd_sc_hd__tapvpwrvgnd_1
XTAP_TAPCELL_ROW_36_547 VGND VPWR sky130_fd_sc_hd__tapvpwrvgnd_1
XFILLER_46_390 VGND VGND VPWR VPWR sky130_fd_sc_hd__fill_2
XFILLER_80_179 VPWR VGND VPWR VGND sky130_ef_sc_hd__decap_12
X_2996_ _0603_ _0948_ VGND VGND VPWR VPWR _0949_ sky130_fd_sc_hd__xnor2_1
X_3617_ net185 net184 net193 net191 VGND VGND VPWR VPWR _1506_ sky130_fd_sc_hd__and4_1
X_3548_ _1426_ _1431_ VGND VGND VPWR VPWR _1437_ sky130_fd_sc_hd__xnor2_1
X_3479_ net430 _1356_ _1387_ _1388_ VGND VGND VPWR VPWR _0309_ sky130_fd_sc_hd__a22o_1
XFILLER_69_482 VGND VGND VPWR VPWR sky130_fd_sc_hd__decap_6
XFILLER_56_110 VPWR VGND VPWR VGND sky130_ef_sc_hd__decap_12
XFILLER_29_379 VGND VGND VPWR VPWR sky130_fd_sc_hd__decap_4
XFILLER_56_132 VGND VGND VPWR VPWR sky130_fd_sc_hd__fill_1
XFILLER_71_113 VPWR VGND VPWR VGND sky130_ef_sc_hd__decap_12
XFILLER_44_23 VGND VGND VPWR VPWR sky130_fd_sc_hd__fill_2
XFILLER_12_202 VGND VGND VPWR VPWR sky130_fd_sc_hd__decap_3
XFILLER_52_360 VGND VGND VPWR VPWR sky130_fd_sc_hd__decap_4
XFILLER_40_533 VGND VGND VPWR VPWR sky130_fd_sc_hd__fill_1
XFILLER_12_246 VGND VGND VPWR VPWR sky130_fd_sc_hd__decap_6
XFILLER_8_228 VGND VGND VPWR VPWR sky130_fd_sc_hd__decap_3
XFILLER_5_39 VPWR VGND VPWR VGND sky130_ef_sc_hd__decap_12
XFILLER_4_445 VPWR VGND VPWR VGND sky130_ef_sc_hd__decap_12
XFILLER_69_42 VPWR VGND VPWR VGND sky130_ef_sc_hd__decap_12
XFILLER_4_489 VPWR VGND VPWR VGND sky130_ef_sc_hd__decap_12
XFILLER_79_279 VGND VGND VPWR VPWR sky130_fd_sc_hd__fill_1
XTAP_TAPCELL_ROW_7_272 VGND VPWR sky130_fd_sc_hd__tapvpwrvgnd_1
XFILLER_75_441 VGND VGND VPWR VPWR sky130_fd_sc_hd__decap_6
XFILLER_47_143 VPWR VGND VPWR VGND sky130_ef_sc_hd__decap_12
XFILLER_35_327 VGND VGND VPWR VPWR sky130_fd_sc_hd__decap_3
XFILLER_62_124 VGND VGND VPWR VPWR sky130_fd_sc_hd__fill_1
XFILLER_90_477 VPWR VGND VPWR VGND sky130_ef_sc_hd__decap_12
XTAP_TAPCELL_ROW_33_517 VGND VPWR sky130_fd_sc_hd__tapvpwrvgnd_1
XFILLER_62_168 VGND VGND VPWR VPWR sky130_fd_sc_hd__fill_2
X_2850_ _0801_ _0802_ VGND VGND VPWR VPWR _0803_ sky130_fd_sc_hd__nor2_1
X_2781_ _0700_ _0731_ VGND VGND VPWR VPWR _0734_ sky130_fd_sc_hd__xnor2_1
X_4520_ clknet_leaf_32_clk net16 _0244_ VGND VGND VPWR VPWR systolic_unit_0.U_10.in_a\[7\]
+ sky130_fd_sc_hd__dfrtp_1
XTAP_TAPCELL_ROW_41_594 VGND VPWR sky130_fd_sc_hd__tapvpwrvgnd_1
X_4451_ clknet_leaf_9_clk net257 _0175_ VGND VGND VPWR VPWR systolic_unit_0.U_00.out_b\[7\]
+ sky130_fd_sc_hd__dfrtp_1
X_3402_ _1313_ _1318_ _1322_ VGND VGND VPWR VPWR _1323_ sky130_fd_sc_hd__and3_1
X_4382_ clknet_leaf_11_clk _0355_ _0106_ VGND VGND VPWR VPWR systolic_unit_0.U_00.acc_1\[2\]
+ sky130_fd_sc_hd__dfrtp_1
X_3333_ _1215_ _1217_ _1252_ _1253_ VGND VGND VPWR VPWR _1254_ sky130_fd_sc_hd__a211oi_1
XFILLER_85_205 VPWR VGND VPWR VGND sky130_ef_sc_hd__decap_12
X_3264_ _1184_ _1182_ VGND VGND VPWR VPWR _1185_ sky130_fd_sc_hd__nand2b_1
XPHY_EDGE_ROW_7_Right_7 VGND VGND VPWR VPWR sky130_fd_sc_hd__decap_3
XFILLER_58_408 VPWR VGND VPWR VGND sky130_ef_sc_hd__decap_12
XFILLER_85_249 VGND VGND VPWR VPWR sky130_fd_sc_hd__decap_6
X_2215_ _1906_ _1913_ VGND VGND VPWR VPWR _1914_ sky130_fd_sc_hd__xor2_1
X_3195_ _1115_ VGND VGND VPWR VPWR _1116_ sky130_fd_sc_hd__inv_2
XFILLER_66_441 VPWR VGND VPWR VGND sky130_ef_sc_hd__decap_12
XFILLER_81_422 VPWR VGND VPWR VGND sky130_ef_sc_hd__decap_12
X_2146_ systolic_unit_0.out_acc_0_r1\[11\] systolic_unit_0.out_acc_1_r1\[11\] net143
+ VGND VGND VPWR VPWR _1873_ sky130_fd_sc_hd__mux2_1
XFILLER_53_113 VPWR VGND VPWR VGND sky130_ef_sc_hd__decap_12
XFILLER_22_522 VGND VGND VPWR VPWR sky130_fd_sc_hd__decap_8
XFILLER_22_533 VPWR VGND VPWR VGND sky130_ef_sc_hd__decap_12
X_2979_ _0813_ _0931_ VGND VGND VPWR VPWR _0932_ sky130_fd_sc_hd__nor2_1
XFILLER_76_205 VGND VGND VPWR VPWR sky130_fd_sc_hd__fill_1
XTAP_TAPCELL_ROW_4_242 VGND VPWR sky130_fd_sc_hd__tapvpwrvgnd_1
XTAP_TAPCELL_ROW_75_918 VGND VPWR sky130_fd_sc_hd__tapvpwrvgnd_1
XFILLER_55_11 VGND VGND VPWR VPWR sky130_fd_sc_hd__decap_3
XFILLER_84_271 VPWR VGND VPWR VGND sky130_ef_sc_hd__decap_12
XFILLER_17_305 VGND VGND VPWR VPWR sky130_fd_sc_hd__fill_2
XFILLER_44_113 VGND VGND VPWR VPWR sky130_fd_sc_hd__decap_3
XFILLER_57_474 VGND VGND VPWR VPWR sky130_fd_sc_hd__decap_8
XFILLER_72_433 VPWR VGND VPWR VGND sky130_ef_sc_hd__decap_12
XFILLER_17_349 VPWR VGND VPWR VGND sky130_ef_sc_hd__decap_12
XFILLER_55_77 VPWR VGND VPWR VGND sky130_ef_sc_hd__decap_12
XFILLER_72_477 VPWR VGND VPWR VGND sky130_ef_sc_hd__decap_12
XFILLER_71_10 VGND VGND VPWR VPWR sky130_fd_sc_hd__fill_1
XFILLER_71_65 VGND VGND VPWR VPWR sky130_fd_sc_hd__decap_8
XFILLER_40_330 VGND VGND VPWR VPWR sky130_fd_sc_hd__fill_2
XTAP_TAPCELL_ROW_10_299 VGND VPWR sky130_fd_sc_hd__tapvpwrvgnd_1
XFILLER_35_146 VGND VGND VPWR VPWR sky130_fd_sc_hd__fill_2
XTAP_TAPCELL_ROW_46_642 VGND VPWR sky130_fd_sc_hd__tapvpwrvgnd_1
X_3951_ net190 net204 _1745_ VGND VGND VPWR VPWR _1825_ sky130_fd_sc_hd__a21o_1
XFILLER_90_285 VPWR VGND VPWR VGND sky130_ef_sc_hd__decap_12
X_2902_ net173 net126 net124 net175 VGND VGND VPWR VPWR _0855_ sky130_fd_sc_hd__a22oi_1
XTAP_TAPCELL_ROW_18_377 VGND VPWR sky130_fd_sc_hd__tapvpwrvgnd_1
XFILLER_91_3 VPWR VGND VPWR VGND sky130_ef_sc_hd__decap_12
X_3882_ _1767_ _1769_ VGND VGND VPWR VPWR _1771_ sky130_fd_sc_hd__or2_1
X_2833_ net128 net169 _0785_ _0783_ VGND VGND VPWR VPWR _0786_ sky130_fd_sc_hd__a31o_1
XFILLER_31_385 VGND VGND VPWR VPWR sky130_fd_sc_hd__decap_6
X_2764_ _0715_ _0716_ _0710_ VGND VGND VPWR VPWR _0717_ sky130_fd_sc_hd__a21oi_1
X_4503_ clknet_2_1__leaf_clk net277 _0227_ VGND VGND VPWR VPWR systolic_unit_0.U_11.switch
+ sky130_fd_sc_hd__dfrtp_4
X_2695_ net167 net120 net119 net170 VGND VGND VPWR VPWR _0648_ sky130_fd_sc_hd__a22oi_1
X_4434_ clknet_leaf_22_clk _0391_ _0158_ VGND VGND VPWR VPWR net53 sky130_fd_sc_hd__dfrtp_1
X_4365_ clknet_leaf_12_clk _0338_ _0089_ VGND VGND VPWR VPWR systolic_unit_0.U_01.acc_0\[1\]
+ sky130_fd_sc_hd__dfrtp_1
X_3316_ _1205_ _1235_ _1236_ VGND VGND VPWR VPWR _1237_ sky130_fd_sc_hd__or3_4
XFILLER_86_525 VGND VGND VPWR VPWR sky130_fd_sc_hd__decap_6
X_4296_ clknet_leaf_27_clk _0277_ _0020_ VGND VGND VPWR VPWR systolic_unit_0.U_11.acc_0\[4\]
+ sky130_fd_sc_hd__dfrtp_1
X_3247_ net111 net159 net109 net156 VGND VGND VPWR VPWR _1168_ sky130_fd_sc_hd__nand4_1
X_3178_ _1095_ _1096_ VGND VGND VPWR VPWR _1099_ sky130_fd_sc_hd__xnor2_1
XTAP_TAPCELL_ROW_1_212 VGND VPWR sky130_fd_sc_hd__tapvpwrvgnd_1
XFILLER_54_411 VGND VGND VPWR VPWR sky130_fd_sc_hd__decap_8
XFILLER_54_455 VGND VGND VPWR VPWR sky130_fd_sc_hd__decap_4
XFILLER_54_477 VGND VGND VPWR VPWR sky130_fd_sc_hd__decap_8
XFILLER_25_69 VGND VGND VPWR VPWR sky130_fd_sc_hd__decap_6
XTAP_TAPCELL_ROW_80_965 VGND VPWR sky130_fd_sc_hd__tapvpwrvgnd_1
XFILLER_10_525 VGND VGND VPWR VPWR sky130_fd_sc_hd__decap_6
XFILLER_22_363 VGND VGND VPWR VPWR sky130_fd_sc_hd__fill_1
XFILLER_41_57 VGND VGND VPWR VPWR sky130_fd_sc_hd__fill_2
XFILLER_1_201 VGND VGND VPWR VPWR sky130_fd_sc_hd__fill_1
XFILLER_1_223 VGND VGND VPWR VPWR sky130_fd_sc_hd__fill_1
XFILLER_2_29 VPWR VGND VPWR VGND sky130_ef_sc_hd__decap_12
XFILLER_66_21 VGND VGND VPWR VPWR sky130_fd_sc_hd__decap_6
XFILLER_66_54 VGND VGND VPWR VPWR sky130_fd_sc_hd__decap_3
XFILLER_66_76 VGND VGND VPWR VPWR sky130_fd_sc_hd__decap_8
XFILLER_17_113 VPWR VGND VPWR VGND sky130_ef_sc_hd__decap_12
XFILLER_32_105 VPWR VGND VPWR VGND sky130_ef_sc_hd__decap_12
XFILLER_82_53 VPWR VGND VPWR VGND sky130_ef_sc_hd__decap_12
XFILLER_32_138 VGND VGND VPWR VPWR sky130_fd_sc_hd__fill_2
XTAP_TAPCELL_ROW_43_612 VGND VPWR sky130_fd_sc_hd__tapvpwrvgnd_1
XFILLER_82_97 VPWR VGND VPWR VGND sky130_ef_sc_hd__decap_12
XTAP_TAPCELL_ROW_15_347 VGND VPWR sky130_fd_sc_hd__tapvpwrvgnd_1
XFILLER_13_385 VGND VGND VPWR VPWR sky130_fd_sc_hd__decap_6
XFILLER_9_312 VPWR VGND VPWR VGND sky130_ef_sc_hd__decap_12
X_2480_ _0462_ _0464_ VGND VGND VPWR VPWR _0465_ sky130_fd_sc_hd__and2b_1
XTAP_TAPCELL_ROW_91_1062 VGND VPWR sky130_fd_sc_hd__tapvpwrvgnd_1
X_4150_ net229 VGND VGND VPWR VPWR _0131_ sky130_fd_sc_hd__inv_2
X_3101_ _1011_ _1018_ _1020_ VGND VGND VPWR VPWR _1022_ sky130_fd_sc_hd__or3_1
X_4081_ net230 VGND VGND VPWR VPWR _0062_ sky130_fd_sc_hd__inv_2
XFILLER_83_517 VPWR VGND VPWR VGND sky130_ef_sc_hd__decap_12
X_3032_ _0910_ _0915_ VGND VGND VPWR VPWR _0972_ sky130_fd_sc_hd__xnor2_1
XFILLER_36_433 VGND VGND VPWR VPWR sky130_fd_sc_hd__decap_8
XFILLER_36_477 VGND VGND VPWR VPWR sky130_fd_sc_hd__decap_8
XFILLER_23_116 VGND VGND VPWR VPWR sky130_fd_sc_hd__fill_1
X_3934_ _1751_ _1752_ VGND VGND VPWR VPWR _1813_ sky130_fd_sc_hd__xnor2_1
X_3865_ _1689_ _1694_ VGND VGND VPWR VPWR _1754_ sky130_fd_sc_hd__xnor2_1
X_2816_ _0741_ _0756_ VGND VGND VPWR VPWR _0769_ sky130_fd_sc_hd__xnor2_1
X_3796_ _1672_ _1678_ VGND VGND VPWR VPWR _1685_ sky130_fd_sc_hd__xor2_2
X_2747_ _0690_ _0691_ VGND VGND VPWR VPWR _0700_ sky130_fd_sc_hd__xor2_1
XFILLER_11_38 VPWR VGND VPWR VGND sky130_ef_sc_hd__decap_12
X_2678_ _0624_ _0630_ _0628_ VGND VGND VPWR VPWR _0631_ sky130_fd_sc_hd__o21ai_1
X_4417_ clknet_leaf_5_clk _0382_ _0141_ VGND VGND VPWR VPWR systolic_unit_0.U_00.acc_0\[13\]
+ sky130_fd_sc_hd__dfrtp_1
X_4348_ clknet_leaf_18_clk _0321_ _0072_ VGND VGND VPWR VPWR systolic_unit_0.U_01.acc_1\[0\]
+ sky130_fd_sc_hd__dfrtp_1
XFILLER_86_333 VPWR VGND VPWR VGND sky130_ef_sc_hd__decap_12
X_4279_ clknet_leaf_17_clk _0260_ _0015_ VGND VGND VPWR VPWR systolic_unit_0.U_11.acc_1\[15\]
+ sky130_fd_sc_hd__dfrtp_1
XFILLER_86_377 VPWR VGND VPWR VGND sky130_ef_sc_hd__decap_12
XFILLER_27_433 VGND VGND VPWR VPWR sky130_fd_sc_hd__fill_1
XFILLER_36_24 VGND VGND VPWR VPWR sky130_fd_sc_hd__decap_4
XFILLER_54_230 VGND VGND VPWR VPWR sky130_fd_sc_hd__fill_2
XFILLER_14_116 VPWR VGND VPWR VGND sky130_ef_sc_hd__decap_12
XTAP_TAPCELL_ROW_12_317 VGND VPWR sky130_fd_sc_hd__tapvpwrvgnd_1
XTAP_TAPCELL_ROW_20_394 VGND VPWR sky130_fd_sc_hd__tapvpwrvgnd_1
XFILLER_89_193 VPWR VGND VPWR VGND sky130_ef_sc_hd__decap_12
XFILLER_77_75 VGND VGND VPWR VPWR sky130_fd_sc_hd__decap_3
XFILLER_65_528 VPWR VGND VPWR VGND sky130_ef_sc_hd__decap_12
XFILLER_93_41 VPWR VGND VPWR VGND sky130_ef_sc_hd__decap_12
XFILLER_93_85 VPWR VGND VPWR VGND sky130_ef_sc_hd__decap_12
XTAP_TAPCELL_ROW_28_472 VGND VPWR sky130_fd_sc_hd__tapvpwrvgnd_1
XFILLER_33_425 VGND VGND VPWR VPWR sky130_fd_sc_hd__decap_3
XFILLER_60_277 VGND VGND VPWR VPWR sky130_fd_sc_hd__decap_8
X_3650_ systolic_unit_0.U_11.acc_1\[7\] systolic_unit_0.U_11.acc_0\[7\] net149 VGND
+ VGND VPWR VPWR _1539_ sky130_fd_sc_hd__mux2_1
X_3581_ _1447_ _1469_ VGND VGND VPWR VPWR _1470_ sky130_fd_sc_hd__nor2_1
Xrebuffer1 net142 VGND VGND VPWR VPWR net276 sky130_fd_sc_hd__dlygate4sd1_1
X_2601_ net368 net88 _0578_ net208 VGND VGND VPWR VPWR _0377_ sky130_fd_sc_hd__a22o_1
XFILLER_54_3 VPWR VGND VPWR VGND sky130_ef_sc_hd__decap_12
X_2532_ _0500_ _0516_ _0499_ VGND VGND VPWR VPWR _0517_ sky130_fd_sc_hd__a21oi_1
X_4202_ net227 VGND VGND VPWR VPWR _0183_ sky130_fd_sc_hd__inv_2
X_2463_ _0437_ _0438_ _0432_ VGND VGND VPWR VPWR _0448_ sky130_fd_sc_hd__o21a_1
X_2394_ systolic_unit_0.U_00.acc_1\[6\] systolic_unit_0.U_00.acc_0\[6\] net208 VGND
+ VGND VPWR VPWR _2093_ sky130_fd_sc_hd__mux2_1
X_4133_ net232 VGND VGND VPWR VPWR _0114_ sky130_fd_sc_hd__inv_2
XFILLER_28_219 VGND VGND VPWR VPWR sky130_fd_sc_hd__fill_1
X_4064_ net225 VGND VGND VPWR VPWR _0045_ sky130_fd_sc_hd__inv_2
X_3015_ _0926_ _0930_ _0929_ VGND VGND VPWR VPWR _0962_ sky130_fd_sc_hd__a21o_1
XFILLER_24_403 VPWR VGND VPWR VGND sky130_ef_sc_hd__decap_12
XFILLER_36_241 VGND VGND VPWR VPWR sky130_fd_sc_hd__decap_8
XTAP_TAPCELL_ROW_54_718 VGND VPWR sky130_fd_sc_hd__tapvpwrvgnd_1
XFILLER_36_274 VGND VGND VPWR VPWR sky130_fd_sc_hd__fill_1
XFILLER_91_391 VGND VGND VPWR VPWR sky130_fd_sc_hd__fill_1
XFILLER_22_15 VGND VGND VPWR VPWR sky130_fd_sc_hd__decap_8
X_3917_ systolic_unit_0.U_01.acc_0\[10\] _1784_ net82 systolic_unit_0.U_11.acc_0\[10\]
+ VGND VGND VPWR VPWR _1801_ sky130_fd_sc_hd__a22o_1
XTAP_TAPCELL_ROW_62_795 VGND VPWR sky130_fd_sc_hd__tapvpwrvgnd_1
X_3848_ _1736_ _1735_ VGND VGND VPWR VPWR _1737_ sky130_fd_sc_hd__nand2b_1
X_3779_ _1656_ _1667_ VGND VGND VPWR VPWR _1668_ sky130_fd_sc_hd__or2_1
Xfanout121 systolic_unit_0.U_01.in_b\[5\] VGND VGND VPWR VPWR net121 sky130_fd_sc_hd__clkbuf_2
Xfanout110 systolic_unit_0.U_10.in_a\[3\] VGND VGND VPWR VPWR net110 sky130_fd_sc_hd__dlymetal6s2s_1
XFILLER_86_141 VPWR VGND VPWR VGND sky130_ef_sc_hd__decap_12
Xfanout165 net166 VGND VGND VPWR VPWR net165 sky130_fd_sc_hd__clkbuf_2
Xfanout143 net278 VGND VGND VPWR VPWR net143 sky130_fd_sc_hd__buf_4
Xfanout154 systolic_unit_0.U_00.out_b\[6\] VGND VGND VPWR VPWR net154 sky130_fd_sc_hd__buf_2
Xfanout132 net133 VGND VGND VPWR VPWR net132 sky130_fd_sc_hd__buf_6
Xfanout176 systolic_unit_0.U_00.out_a\[1\] VGND VGND VPWR VPWR net176 sky130_fd_sc_hd__clkbuf_2
Xfanout198 net199 VGND VGND VPWR VPWR net198 sky130_fd_sc_hd__buf_2
Xfanout187 systolic_unit_0.U_01.out_b\[1\] VGND VGND VPWR VPWR net187 sky130_fd_sc_hd__buf_2
XFILLER_47_23 VPWR VGND VPWR VGND sky130_ef_sc_hd__decap_12
XFILLER_59_366 VGND VGND VPWR VPWR sky130_fd_sc_hd__fill_1
XFILLER_47_89 VGND VGND VPWR VPWR sky130_fd_sc_hd__decap_6
XFILLER_63_33 VPWR VGND VPWR VGND sky130_ef_sc_hd__decap_12
XFILLER_70_553 VGND VGND VPWR VPWR sky130_fd_sc_hd__fill_1
XFILLER_70_531 VGND VGND VPWR VPWR sky130_fd_sc_hd__fill_1
XFILLER_15_447 VGND VGND VPWR VPWR sky130_fd_sc_hd__fill_1
XTAP_TAPCELL_ROW_25_442 VGND VPWR sky130_fd_sc_hd__tapvpwrvgnd_1
XFILLER_30_439 VGND VGND VPWR VPWR sky130_fd_sc_hd__fill_1
XFILLER_10_141 VGND VGND VPWR VPWR sky130_fd_sc_hd__decap_6
XFILLER_88_41 VPWR VGND VPWR VGND sky130_ef_sc_hd__decap_12
XFILLER_88_85 VPWR VGND VPWR VGND sky130_ef_sc_hd__decap_12
XPHY_EDGE_ROW_0_Left_94 VGND VGND VPWR VPWR sky130_fd_sc_hd__decap_3
XFILLER_2_395 VPWR VGND VPWR VGND sky130_ef_sc_hd__decap_12
XFILLER_38_528 VGND VGND VPWR VPWR sky130_fd_sc_hd__fill_1
XFILLER_92_133 VGND VGND VPWR VPWR sky130_fd_sc_hd__decap_6
XFILLER_65_325 VGND VGND VPWR VPWR sky130_fd_sc_hd__fill_1
XFILLER_92_177 VPWR VGND VPWR VGND sky130_ef_sc_hd__decap_12
XFILLER_33_211 VPWR VGND VPWR VGND sky130_ef_sc_hd__decap_12
XFILLER_73_391 VGND VGND VPWR VPWR sky130_fd_sc_hd__fill_1
XFILLER_21_428 VGND VGND VPWR VPWR sky130_fd_sc_hd__fill_1
XFILLER_33_266 VGND VGND VPWR VPWR sky130_fd_sc_hd__decap_8
X_3702_ _1589_ _1590_ _1584_ VGND VGND VPWR VPWR _1591_ sky130_fd_sc_hd__a21boi_1
X_3633_ _1501_ _1512_ VGND VGND VPWR VPWR _1522_ sky130_fd_sc_hd__xor2_1
X_3564_ _1451_ _1452_ net197 net178 VGND VGND VPWR VPWR _1453_ sky130_fd_sc_hd__and4bb_1
X_3495_ systolic_unit_0.U_00.acc_0\[0\] net207 net134 VGND VGND VPWR VPWR _1401_ sky130_fd_sc_hd__a21o_1
X_2515_ _0485_ _0489_ _0498_ VGND VGND VPWR VPWR _0500_ sky130_fd_sc_hd__a21o_1
X_2446_ _2109_ _0430_ VGND VGND VPWR VPWR _0431_ sky130_fd_sc_hd__and2_1
XFILLER_68_141 VPWR VGND VPWR VGND sky130_ef_sc_hd__decap_12
X_4116_ net249 VGND VGND VPWR VPWR _0097_ sky130_fd_sc_hd__inv_2
X_2377_ _2044_ _2050_ _2049_ VGND VGND VPWR VPWR _2076_ sky130_fd_sc_hd__a21o_1
XFILLER_83_111 VGND VGND VPWR VPWR sky130_fd_sc_hd__fill_1
X_4047_ net250 VGND VGND VPWR VPWR _0028_ sky130_fd_sc_hd__inv_2
XTAP_TAPCELL_ROW_22_412 VGND VPWR sky130_fd_sc_hd__tapvpwrvgnd_1
XFILLER_20_483 VGND VGND VPWR VPWR sky130_fd_sc_hd__decap_4
XFILLER_20_494 VPWR VGND VPWR VGND sky130_ef_sc_hd__decap_12
XPHY_EDGE_ROW_18_Left_112 VGND VGND VPWR VPWR sky130_fd_sc_hd__decap_3
XFILLER_3_159 VGND VGND VPWR VPWR sky130_fd_sc_hd__fill_1
XFILLER_79_417 VPWR VGND VPWR VGND sky130_ef_sc_hd__decap_12
XFILLER_47_303 VPWR VGND VPWR VGND sky130_ef_sc_hd__decap_12
XFILLER_87_483 VPWR VGND VPWR VGND sky130_ef_sc_hd__decap_12
XFILLER_74_111 VGND VGND VPWR VPWR sky130_fd_sc_hd__fill_1
XFILLER_59_196 VGND VGND VPWR VPWR sky130_fd_sc_hd__decap_8
XPHY_EDGE_ROW_27_Left_121 VGND VGND VPWR VPWR sky130_fd_sc_hd__decap_3
XFILLER_74_188 VGND VGND VPWR VPWR sky130_fd_sc_hd__decap_8
XFILLER_74_65 VGND VGND VPWR VPWR sky130_fd_sc_hd__decap_6
XFILLER_15_233 VGND VGND VPWR VPWR sky130_fd_sc_hd__fill_2
XFILLER_43_553 VGND VGND VPWR VPWR sky130_fd_sc_hd__fill_1
XFILLER_90_53 VPWR VGND VPWR VGND sky130_ef_sc_hd__decap_12
XFILLER_90_97 VPWR VGND VPWR VGND sky130_ef_sc_hd__decap_12
XFILLER_11_461 VPWR VGND VPWR VGND sky130_ef_sc_hd__decap_12
XPHY_EDGE_ROW_36_Left_130 VGND VGND VPWR VPWR sky130_fd_sc_hd__decap_3
X_2300_ _1957_ _1997_ VGND VGND VPWR VPWR _1999_ sky130_fd_sc_hd__xor2_1
X_3280_ _1195_ _1197_ VGND VGND VPWR VPWR _1201_ sky130_fd_sc_hd__xnor2_1
X_2231_ net215 net258 _1928_ VGND VGND VPWR VPWR _1930_ sky130_fd_sc_hd__a21oi_1
XFILLER_78_483 VPWR VGND VPWR VGND sky130_ef_sc_hd__decap_12
XFILLER_17_3 VGND VGND VPWR VPWR sky130_fd_sc_hd__decap_8
X_2162_ systolic_unit_0.out_acc_0_r1\[3\] systolic_unit_0.out_acc_1_r1\[3\] net151
+ VGND VGND VPWR VPWR _1881_ sky130_fd_sc_hd__mux2_1
XFILLER_38_336 VPWR VGND VPWR VGND sky130_ef_sc_hd__decap_12
XFILLER_65_111 VGND VGND VPWR VPWR sky130_fd_sc_hd__fill_1
XTAP_TAPCELL_ROW_88_1034 VGND VPWR sky130_fd_sc_hd__tapvpwrvgnd_1
XTAP_TAPCELL_ROW_64_813 VGND VPWR sky130_fd_sc_hd__tapvpwrvgnd_1
XFILLER_34_531 VGND VGND VPWR VPWR sky130_fd_sc_hd__fill_1
XFILLER_34_553 VGND VGND VPWR VPWR sky130_fd_sc_hd__fill_1
XTAP_TAPCELL_ROW_36_548 VGND VPWR sky130_fd_sc_hd__tapvpwrvgnd_1
XTAP_TAPCELL_ROW_72_890 VGND VPWR sky130_fd_sc_hd__tapvpwrvgnd_1
X_2995_ _0594_ _0947_ VGND VGND VPWR VPWR _0948_ sky130_fd_sc_hd__xor2_1
X_3616_ _1503_ _1504_ VGND VGND VPWR VPWR _1505_ sky130_fd_sc_hd__and2_1
X_3547_ _1434_ _1435_ VGND VGND VPWR VPWR _1436_ sky130_fd_sc_hd__nand2b_1
X_3478_ systolic_unit_0.U_00.acc_0\[4\] net207 net135 VGND VGND VPWR VPWR _1388_ sky130_fd_sc_hd__a21o_1
XFILLER_69_461 VPWR VGND VPWR VGND sky130_ef_sc_hd__decap_12
X_2429_ _2125_ _2126_ _2123_ VGND VGND VPWR VPWR _2128_ sky130_fd_sc_hd__a21bo_1
XFILLER_56_122 VGND VGND VPWR VPWR sky130_fd_sc_hd__decap_6
XFILLER_84_475 VGND VGND VPWR VPWR sky130_fd_sc_hd__fill_1
XFILLER_44_306 VGND VGND VPWR VPWR sky130_fd_sc_hd__fill_2
XFILLER_71_125 VGND VGND VPWR VPWR sky130_fd_sc_hd__decap_4
XFILLER_44_35 VGND VGND VPWR VPWR sky130_fd_sc_hd__decap_3
XFILLER_71_169 VGND VGND VPWR VPWR sky130_fd_sc_hd__fill_2
XFILLER_25_553 VGND VGND VPWR VPWR sky130_fd_sc_hd__fill_1
XFILLER_60_34 VPWR VGND VPWR VGND sky130_ef_sc_hd__decap_12
XFILLER_60_89 VGND VGND VPWR VPWR sky130_fd_sc_hd__fill_1
XFILLER_4_457 VPWR VGND VPWR VGND sky130_ef_sc_hd__decap_12
XFILLER_69_54 VGND VGND VPWR VPWR sky130_fd_sc_hd__fill_2
XFILLER_79_225 VPWR VGND VPWR VGND sky130_ef_sc_hd__decap_12
XFILLER_67_409 VPWR VGND VPWR VGND sky130_ef_sc_hd__decap_12
XTAP_TAPCELL_ROW_78_938 VGND VPWR sky130_fd_sc_hd__tapvpwrvgnd_1
XFILLER_47_155 VGND VGND VPWR VPWR sky130_fd_sc_hd__decap_3
XFILLER_75_475 VPWR VGND VPWR VGND sky130_ef_sc_hd__decap_12
XFILLER_16_531 VGND VGND VPWR VPWR sky130_fd_sc_hd__fill_1
XFILLER_90_489 VPWR VGND VPWR VGND sky130_ef_sc_hd__decap_12
XFILLER_16_553 VGND VGND VPWR VPWR sky130_fd_sc_hd__fill_1
XTAP_TAPCELL_ROW_33_518 VGND VPWR sky130_fd_sc_hd__tapvpwrvgnd_1
XFILLER_50_309 VGND VGND VPWR VPWR sky130_fd_sc_hd__fill_2
X_2780_ _0722_ _0727_ _0725_ VGND VGND VPWR VPWR _0733_ sky130_fd_sc_hd__a21o_1
XTAP_TAPCELL_ROW_41_595 VGND VPWR sky130_fd_sc_hd__tapvpwrvgnd_1
XFILLER_7_262 VPWR VGND VPWR VGND sky130_ef_sc_hd__decap_12
X_4450_ clknet_leaf_5_clk net259 _0174_ VGND VGND VPWR VPWR systolic_unit_0.U_00.out_b\[6\]
+ sky130_fd_sc_hd__dfrtp_2
X_3401_ _1308_ _1319_ _1321_ VGND VGND VPWR VPWR _1322_ sky130_fd_sc_hd__nor3_1
X_4381_ clknet_leaf_4_clk _0354_ _0105_ VGND VGND VPWR VPWR systolic_unit_0.U_00.acc_1\[1\]
+ sky130_fd_sc_hd__dfrtp_1
X_3332_ _1190_ _1250_ _1251_ VGND VGND VPWR VPWR _1253_ sky130_fd_sc_hd__a21oi_1
XFILLER_85_217 VGND VGND VPWR VPWR sky130_fd_sc_hd__decap_6
X_3263_ _1144_ _1183_ VGND VGND VPWR VPWR _1184_ sky130_fd_sc_hd__or2_1
X_3194_ _1078_ _1103_ _1114_ VGND VGND VPWR VPWR _1115_ sky130_fd_sc_hd__nand3_1
X_2214_ systolic_unit_0.U_00.acc_1\[14\] systolic_unit_0.U_00.acc_0\[14\] net211 VGND
+ VGND VPWR VPWR _1913_ sky130_fd_sc_hd__mux2_1
XFILLER_38_133 VGND VGND VPWR VPWR sky130_fd_sc_hd__decap_6
X_2145_ net331 _1872_ net90 VGND VGND VPWR VPWR _0413_ sky130_fd_sc_hd__mux2_1
XFILLER_66_453 VPWR VGND VPWR VGND sky130_ef_sc_hd__decap_12
XFILLER_66_486 VPWR VGND VPWR VGND sky130_ef_sc_hd__decap_12
XFILLER_81_434 VPWR VGND VPWR VGND sky130_ef_sc_hd__decap_12
XFILLER_53_125 VGND VGND VPWR VPWR sky130_fd_sc_hd__decap_8
XFILLER_53_169 VPWR VGND VPWR VGND sky130_ef_sc_hd__decap_12
XFILLER_14_27 VGND VGND VPWR VPWR sky130_fd_sc_hd__fill_1
XFILLER_22_545 VGND VGND VPWR VPWR sky130_fd_sc_hd__decap_8
X_2978_ _0929_ _0930_ VGND VGND VPWR VPWR _0931_ sky130_fd_sc_hd__nand2b_1
XFILLER_30_15 VPWR VGND VPWR VGND sky130_ef_sc_hd__decap_12
XFILLER_1_405 VPWR VGND VPWR VGND sky130_ef_sc_hd__decap_12
XFILLER_1_449 VPWR VGND VPWR VGND sky130_ef_sc_hd__decap_12
XFILLER_39_57 VGND VGND VPWR VPWR sky130_fd_sc_hd__fill_1
XTAP_TAPCELL_ROW_4_243 VGND VPWR sky130_fd_sc_hd__tapvpwrvgnd_1
XFILLER_57_431 VGND VGND VPWR VPWR sky130_fd_sc_hd__decap_3
XFILLER_84_261 VGND VGND VPWR VPWR sky130_fd_sc_hd__decap_3
XFILLER_29_166 VGND VGND VPWR VPWR sky130_fd_sc_hd__fill_2
XFILLER_84_283 VPWR VGND VPWR VGND sky130_ef_sc_hd__decap_12
XFILLER_72_445 VPWR VGND VPWR VGND sky130_ef_sc_hd__decap_12
XFILLER_44_136 VGND VGND VPWR VPWR sky130_fd_sc_hd__decap_4
XFILLER_72_489 VPWR VGND VPWR VGND sky130_ef_sc_hd__decap_12
XFILLER_55_89 VGND VGND VPWR VPWR sky130_fd_sc_hd__decap_4
XFILLER_9_505 VPWR VGND VPWR VGND sky130_ef_sc_hd__decap_12
XFILLER_40_397 VGND VGND VPWR VPWR sky130_fd_sc_hd__decap_3
XFILLER_20_92 VGND VGND VPWR VPWR sky130_fd_sc_hd__fill_2
XFILLER_82_209 VGND VGND VPWR VPWR sky130_fd_sc_hd__decap_8
XFILLER_48_475 VGND VGND VPWR VPWR sky130_fd_sc_hd__fill_1
Xhold90 systolic_unit_0.U_01.acc_1\[2\] VGND VGND VPWR VPWR net365 sky130_fd_sc_hd__dlygate4sd3_1
XTAP_TAPCELL_ROW_46_643 VGND VPWR sky130_fd_sc_hd__tapvpwrvgnd_1
XFILLER_16_350 VPWR VGND VPWR VGND sky130_ef_sc_hd__decap_12
X_3950_ systolic_unit_0.U_01.acc_0\[1\] net75 net82 net381 _1824_ VGND VGND VPWR VPWR
+ _0274_ sky130_fd_sc_hd__a221o_1
XFILLER_90_297 VGND VGND VPWR VPWR sky130_fd_sc_hd__decap_3
X_2901_ net176 net173 net126 net124 VGND VGND VPWR VPWR _0854_ sky130_fd_sc_hd__and4_1
X_3881_ _1701_ _1759_ _1765_ _1769_ VGND VGND VPWR VPWR _1770_ sky130_fd_sc_hd__a211o_1
XFILLER_84_3 VPWR VGND VPWR VGND sky130_ef_sc_hd__decap_12
X_2832_ _0781_ _0782_ VGND VGND VPWR VPWR _0785_ sky130_fd_sc_hd__xnor2_1
X_2763_ _0703_ _0709_ VGND VGND VPWR VPWR _0716_ sky130_fd_sc_hd__xor2_1
X_4502_ clknet_leaf_11_clk net207 _0226_ VGND VGND VPWR VPWR systolic_unit_0.U_01.drain_0
+ sky130_fd_sc_hd__dfrtp_2
X_2694_ net169 net167 net120 net119 VGND VGND VPWR VPWR _0647_ sky130_fd_sc_hd__and4_1
XFILLER_6_83 VGND VGND VPWR VPWR sky130_fd_sc_hd__fill_1
X_4433_ clknet_leaf_11_clk _0390_ _0157_ VGND VGND VPWR VPWR net52 sky130_fd_sc_hd__dfrtp_1
X_4364_ clknet_leaf_18_clk _0337_ _0088_ VGND VGND VPWR VPWR systolic_unit_0.U_01.acc_0\[0\]
+ sky130_fd_sc_hd__dfrtp_1
X_3315_ _1202_ _1203_ _1204_ VGND VGND VPWR VPWR _1236_ sky130_fd_sc_hd__a21oi_1
X_4295_ clknet_leaf_19_clk _0276_ _0019_ VGND VGND VPWR VPWR systolic_unit_0.U_11.acc_0\[3\]
+ sky130_fd_sc_hd__dfrtp_1
X_3246_ _1140_ _1153_ _1152_ VGND VGND VPWR VPWR _1167_ sky130_fd_sc_hd__a21oi_1
XFILLER_39_420 VGND VGND VPWR VPWR sky130_fd_sc_hd__fill_1
X_3177_ net162 net101 _1097_ VGND VGND VPWR VPWR _1098_ sky130_fd_sc_hd__nand3_1
XTAP_TAPCELL_ROW_1_213 VGND VPWR sky130_fd_sc_hd__tapvpwrvgnd_1
XFILLER_26_136 VGND VGND VPWR VPWR sky130_fd_sc_hd__fill_1
XFILLER_54_445 VGND VGND VPWR VPWR sky130_fd_sc_hd__fill_2
XFILLER_25_15 VPWR VGND VPWR VGND sky130_ef_sc_hd__decap_12
XFILLER_26_147 VGND VGND VPWR VPWR sky130_fd_sc_hd__decap_8
XTAP_TAPCELL_ROW_80_966 VGND VPWR sky130_fd_sc_hd__tapvpwrvgnd_1
XFILLER_1_257 VGND VGND VPWR VPWR sky130_fd_sc_hd__decap_3
XFILLER_57_261 VGND VGND VPWR VPWR sky130_fd_sc_hd__decap_6
XFILLER_64_209 VPWR VGND VPWR VGND sky130_ef_sc_hd__decap_12
XFILLER_72_231 VGND VGND VPWR VPWR sky130_fd_sc_hd__decap_6
XFILLER_17_125 VPWR VGND VPWR VGND sky130_ef_sc_hd__decap_12
XFILLER_72_253 VPWR VGND VPWR VGND sky130_ef_sc_hd__decap_12
XFILLER_45_467 VPWR VGND VPWR VGND sky130_ef_sc_hd__decap_12
XFILLER_82_65 VPWR VGND VPWR VGND sky130_ef_sc_hd__decap_12
XFILLER_32_117 VGND VGND VPWR VPWR sky130_fd_sc_hd__decap_4
XTAP_TAPCELL_ROW_43_613 VGND VPWR sky130_fd_sc_hd__tapvpwrvgnd_1
XTAP_TAPCELL_ROW_15_348 VGND VPWR sky130_fd_sc_hd__tapvpwrvgnd_1
XFILLER_9_324 VPWR VGND VPWR VGND sky130_ef_sc_hd__decap_12
XFILLER_40_161 VGND VGND VPWR VPWR sky130_fd_sc_hd__decap_4
XTAP_TAPCELL_ROW_51_690 VGND VPWR sky130_fd_sc_hd__tapvpwrvgnd_1
XFILLER_5_541 VPWR VGND VPWR VGND sky130_ef_sc_hd__decap_12
XTAP_TAPCELL_ROW_91_1063 VGND VPWR sky130_fd_sc_hd__tapvpwrvgnd_1
XFILLER_68_504 VPWR VGND VPWR VGND sky130_ef_sc_hd__decap_12
X_3100_ _1018_ _1020_ _1011_ VGND VGND VPWR VPWR _1021_ sky130_fd_sc_hd__o21ai_1
X_4080_ net225 VGND VGND VPWR VPWR _0061_ sky130_fd_sc_hd__inv_2
XFILLER_83_529 VPWR VGND VPWR VGND sky130_ef_sc_hd__decap_12
X_3031_ net404 net84 _0971_ net138 VGND VGND VPWR VPWR _0340_ sky130_fd_sc_hd__a22o_1
XFILLER_63_264 VGND VGND VPWR VPWR sky130_fd_sc_hd__decap_8
XFILLER_23_106 VGND VGND VPWR VPWR sky130_fd_sc_hd__fill_1
XFILLER_23_128 VGND VGND VPWR VPWR sky130_fd_sc_hd__decap_8
X_3933_ net146 _1811_ _1812_ VGND VGND VPWR VPWR _0279_ sky130_fd_sc_hd__a21o_1
XFILLER_51_459 VGND VGND VPWR VPWR sky130_fd_sc_hd__decap_8
X_3864_ _1720_ _1750_ _1752_ _1739_ VGND VGND VPWR VPWR _1753_ sky130_fd_sc_hd__o31a_1
X_2815_ _0741_ _0756_ VGND VGND VPWR VPWR _0768_ sky130_fd_sc_hd__nand2_1
X_3795_ _1680_ _1683_ VGND VGND VPWR VPWR _1684_ sky130_fd_sc_hd__xnor2_1
X_2746_ _0693_ _0694_ _0686_ _0689_ VGND VGND VPWR VPWR _0699_ sky130_fd_sc_hd__a211o_1
X_2677_ _0628_ _0629_ VGND VGND VPWR VPWR _0630_ sky130_fd_sc_hd__nand2_1
X_4416_ clknet_leaf_5_clk _0381_ _0140_ VGND VGND VPWR VPWR systolic_unit_0.U_00.acc_0\[12\]
+ sky130_fd_sc_hd__dfrtp_1
XFILLER_86_301 VGND VGND VPWR VPWR sky130_fd_sc_hd__fill_1
X_4347_ clknet_leaf_26_clk net102 _0071_ VGND VGND VPWR VPWR systolic_unit_0.U_10.out_a\[7\]
+ sky130_fd_sc_hd__dfrtp_1
XFILLER_86_345 VPWR VGND VPWR VGND sky130_ef_sc_hd__decap_12
X_4278_ clknet_leaf_16_clk _0259_ _0014_ VGND VGND VPWR VPWR systolic_unit_0.U_11.acc_1\[14\]
+ sky130_fd_sc_hd__dfrtp_1
XFILLER_86_389 VPWR VGND VPWR VGND sky130_ef_sc_hd__decap_12
X_3229_ _1146_ _1148_ VGND VGND VPWR VPWR _1150_ sky130_fd_sc_hd__xnor2_1
XFILLER_27_467 VGND VGND VPWR VPWR sky130_fd_sc_hd__fill_1
XFILLER_54_253 VPWR VGND VPWR VGND sky130_ef_sc_hd__decap_12
XFILLER_14_128 VPWR VGND VPWR VGND sky130_ef_sc_hd__decap_12
XFILLER_54_286 VGND VGND VPWR VPWR sky130_fd_sc_hd__fill_1
XTAP_TAPCELL_ROW_12_318 VGND VPWR sky130_fd_sc_hd__tapvpwrvgnd_1
XFILLER_22_194 VGND VGND VPWR VPWR sky130_fd_sc_hd__fill_2
XFILLER_6_305 VGND VGND VPWR VPWR sky130_fd_sc_hd__decap_3
XTAP_TAPCELL_ROW_20_395 VGND VPWR sky130_fd_sc_hd__tapvpwrvgnd_1
XFILLER_2_533 VPWR VGND VPWR VGND sky130_ef_sc_hd__decap_12
XFILLER_89_161 VGND VGND VPWR VPWR sky130_fd_sc_hd__decap_6
XFILLER_93_53 VGND VGND VPWR VPWR sky130_fd_sc_hd__decap_3
XFILLER_18_456 VGND VGND VPWR VPWR sky130_fd_sc_hd__fill_1
XFILLER_45_242 VGND VGND VPWR VPWR sky130_fd_sc_hd__decap_4
XFILLER_93_97 VPWR VGND VPWR VGND sky130_ef_sc_hd__decap_12
XFILLER_33_437 VGND VGND VPWR VPWR sky130_fd_sc_hd__decap_8
XFILLER_13_172 VPWR VGND VPWR VGND sky130_ef_sc_hd__decap_12
Xrebuffer2 net142 VGND VGND VPWR VPWR net277 sky130_fd_sc_hd__dlygate4sd1_1
X_3580_ net182 net192 _1446_ VGND VGND VPWR VPWR _1469_ sky130_fd_sc_hd__a21oi_1
X_2600_ _0524_ _0529_ VGND VGND VPWR VPWR _0578_ sky130_fd_sc_hd__xor2_1
X_2531_ _0507_ _0508_ _0515_ VGND VGND VPWR VPWR _0516_ sky130_fd_sc_hd__a21o_1
XFILLER_5_393 VPWR VGND VPWR VGND sky130_ef_sc_hd__decap_12
X_4201_ net222 VGND VGND VPWR VPWR _0182_ sky130_fd_sc_hd__inv_2
X_2462_ _0444_ _0445_ _0437_ _0439_ VGND VGND VPWR VPWR _0447_ sky130_fd_sc_hd__a211o_1
X_2393_ _2051_ _2076_ _2091_ VGND VGND VPWR VPWR _2092_ sky130_fd_sc_hd__and3_1
XFILLER_3_51 VGND VGND VPWR VPWR sky130_fd_sc_hd__decap_4
X_4132_ net223 VGND VGND VPWR VPWR _0113_ sky130_fd_sc_hd__inv_2
XFILLER_28_209 VGND VGND VPWR VPWR sky130_fd_sc_hd__decap_3
X_4063_ net225 VGND VGND VPWR VPWR _0044_ sky130_fd_sc_hd__inv_2
XFILLER_83_337 VPWR VGND VPWR VGND sky130_ef_sc_hd__decap_12
X_3014_ systolic_unit_0.U_01.acc_0\[10\] net85 _0961_ net141 VGND VGND VPWR VPWR _0347_
+ sky130_fd_sc_hd__a22o_1
XTAP_TAPCELL_ROW_54_719 VGND VPWR sky130_fd_sc_hd__tapvpwrvgnd_1
XFILLER_24_415 VGND VGND VPWR VPWR sky130_fd_sc_hd__decap_4
X_3916_ _1611_ _1768_ VGND VGND VPWR VPWR _1800_ sky130_fd_sc_hd__xor2_1
X_3847_ _1703_ _1718_ _1717_ VGND VGND VPWR VPWR _1736_ sky130_fd_sc_hd__a21oi_1
X_3778_ _1665_ _1666_ _1664_ VGND VGND VPWR VPWR _1667_ sky130_fd_sc_hd__a21boi_2
X_2729_ net170 net121 net119 net172 VGND VGND VPWR VPWR _0682_ sky130_fd_sc_hd__a22oi_1
Xfanout122 systolic_unit_0.U_01.in_b\[4\] VGND VGND VPWR VPWR net122 sky130_fd_sc_hd__buf_2
Xfanout111 systolic_unit_0.U_10.in_a\[2\] VGND VGND VPWR VPWR net111 sky130_fd_sc_hd__buf_2
Xfanout100 _1866_ VGND VGND VPWR VPWR net100 sky130_fd_sc_hd__clkbuf_2
Xfanout155 systolic_unit_0.U_00.out_b\[5\] VGND VGND VPWR VPWR net155 sky130_fd_sc_hd__buf_2
Xfanout133 net136 VGND VGND VPWR VPWR net133 sky130_fd_sc_hd__clkbuf_4
Xfanout144 net145 VGND VGND VPWR VPWR net144 sky130_fd_sc_hd__buf_4
Xfanout166 systolic_unit_0.U_00.out_a\[7\] VGND VGND VPWR VPWR net166 sky130_fd_sc_hd__clkbuf_2
XFILLER_86_153 VPWR VGND VPWR VGND sky130_ef_sc_hd__decap_12
Xfanout199 systolic_unit_0.U_10.out_a\[3\] VGND VGND VPWR VPWR net199 sky130_fd_sc_hd__clkbuf_2
XFILLER_47_35 VPWR VGND VPWR VGND sky130_ef_sc_hd__decap_12
Xfanout188 systolic_unit_0.U_01.out_b\[1\] VGND VGND VPWR VPWR net188 sky130_fd_sc_hd__clkbuf_2
XFILLER_59_389 VGND VGND VPWR VPWR sky130_fd_sc_hd__decap_3
Xfanout177 systolic_unit_0.U_00.out_a\[0\] VGND VGND VPWR VPWR net177 sky130_fd_sc_hd__buf_2
XFILLER_86_197 VPWR VGND VPWR VGND sky130_ef_sc_hd__decap_12
XPHY_EDGE_ROW_29_Right_29 VGND VGND VPWR VPWR sky130_fd_sc_hd__decap_3
XFILLER_63_67 VGND VGND VPWR VPWR sky130_fd_sc_hd__decap_4
XTAP_TAPCELL_ROW_25_443 VGND VPWR sky130_fd_sc_hd__tapvpwrvgnd_1
XFILLER_8_29 VPWR VGND VPWR VGND sky130_ef_sc_hd__decap_12
XPHY_EDGE_ROW_38_Right_38 VGND VGND VPWR VPWR sky130_fd_sc_hd__decap_3
XFILLER_10_197 VGND VGND VPWR VPWR sky130_fd_sc_hd__decap_8
XFILLER_88_53 VPWR VGND VPWR VGND sky130_ef_sc_hd__decap_12
XFILLER_2_341 VGND VGND VPWR VPWR sky130_fd_sc_hd__decap_3
XFILLER_88_97 VPWR VGND VPWR VGND sky130_ef_sc_hd__decap_12
XPHY_EDGE_ROW_47_Right_47 VGND VGND VPWR VPWR sky130_fd_sc_hd__decap_3
XFILLER_80_307 VGND VGND VPWR VPWR sky130_fd_sc_hd__fill_1
XFILLER_92_189 VGND VGND VPWR VPWR sky130_fd_sc_hd__decap_6
XFILLER_18_253 VGND VGND VPWR VPWR sky130_fd_sc_hd__fill_2
XFILLER_33_223 VGND VGND VPWR VPWR sky130_fd_sc_hd__fill_1
XFILLER_14_481 VGND VGND VPWR VPWR sky130_fd_sc_hd__fill_1
XPHY_EDGE_ROW_56_Right_56 VGND VGND VPWR VPWR sky130_fd_sc_hd__decap_3
X_3701_ _1577_ _1583_ VGND VGND VPWR VPWR _1590_ sky130_fd_sc_hd__xor2_1
X_3632_ _1516_ _1520_ VGND VGND VPWR VPWR _1521_ sky130_fd_sc_hd__xor2_1
X_3563_ net181 net193 systolic_unit_0.U_01.out_b\[6\] net194 VGND VGND VPWR VPWR _1452_
+ sky130_fd_sc_hd__a22oi_1
X_3494_ _1321_ _1399_ net96 VGND VGND VPWR VPWR _1400_ sky130_fd_sc_hd__a21o_1
X_2514_ _0485_ _0489_ _0498_ VGND VGND VPWR VPWR _0499_ sky130_fd_sc_hd__and3_1
X_2445_ net274 net261 _2108_ VGND VGND VPWR VPWR _0430_ sky130_fd_sc_hd__a21o_1
XPHY_EDGE_ROW_65_Right_65 VGND VGND VPWR VPWR sky130_fd_sc_hd__decap_3
XFILLER_68_153 VPWR VGND VPWR VGND sky130_ef_sc_hd__decap_12
X_2376_ _2053_ _2066_ _2065_ VGND VGND VPWR VPWR _2075_ sky130_fd_sc_hd__o21ai_1
X_4115_ net249 VGND VGND VPWR VPWR _0096_ sky130_fd_sc_hd__inv_2
XFILLER_68_197 VPWR VGND VPWR VGND sky130_ef_sc_hd__decap_12
XFILLER_37_540 VGND VGND VPWR VPWR sky130_fd_sc_hd__decap_3
XTAP_TAPCELL_ROW_39_568 VGND VPWR sky130_fd_sc_hd__tapvpwrvgnd_1
X_4046_ net248 VGND VGND VPWR VPWR _0027_ sky130_fd_sc_hd__inv_2
XFILLER_56_348 VGND VGND VPWR VPWR sky130_fd_sc_hd__decap_8
XFILLER_83_167 VGND VGND VPWR VPWR sky130_fd_sc_hd__fill_1
XFILLER_24_245 VGND VGND VPWR VPWR sky130_fd_sc_hd__decap_6
XPHY_EDGE_ROW_74_Right_74 VGND VGND VPWR VPWR sky130_fd_sc_hd__decap_3
XTAP_TAPCELL_ROW_22_413 VGND VPWR sky130_fd_sc_hd__tapvpwrvgnd_1
XFILLER_33_48 VGND VGND VPWR VPWR sky130_fd_sc_hd__fill_1
XFILLER_20_473 VGND VGND VPWR VPWR sky130_fd_sc_hd__decap_3
XTAP_TAPCELL_ROW_30_490 VGND VPWR sky130_fd_sc_hd__tapvpwrvgnd_1
XFILLER_3_105 VGND VGND VPWR VPWR sky130_fd_sc_hd__decap_6
XPHY_EDGE_ROW_83_Right_83 VGND VGND VPWR VPWR sky130_fd_sc_hd__decap_3
XFILLER_79_429 VGND VGND VPWR VPWR sky130_fd_sc_hd__decap_4
XFILLER_87_495 VGND VGND VPWR VPWR sky130_fd_sc_hd__decap_8
XFILLER_47_315 VGND VGND VPWR VPWR sky130_fd_sc_hd__fill_1
XFILLER_47_337 VGND VGND VPWR VPWR sky130_fd_sc_hd__decap_6
XPHY_EDGE_ROW_92_Right_92 VGND VGND VPWR VPWR sky130_fd_sc_hd__decap_3
XFILLER_15_223 VGND VGND VPWR VPWR sky130_fd_sc_hd__fill_1
XFILLER_90_65 VPWR VGND VPWR VGND sky130_ef_sc_hd__decap_12
XFILLER_11_473 VPWR VGND VPWR VGND sky130_ef_sc_hd__decap_12
X_2230_ net215 net258 _1928_ VGND VGND VPWR VPWR _1929_ sky130_fd_sc_hd__and3_1
XFILLER_93_421 VPWR VGND VPWR VGND sky130_ef_sc_hd__decap_12
XFILLER_78_495 VPWR VGND VPWR VGND sky130_ef_sc_hd__decap_12
X_2161_ net346 _1880_ net90 VGND VGND VPWR VPWR _0405_ sky130_fd_sc_hd__mux2_1
XTAP_TAPCELL_ROW_88_1035 VGND VPWR sky130_fd_sc_hd__tapvpwrvgnd_1
XFILLER_38_348 VPWR VGND VPWR VGND sky130_ef_sc_hd__decap_12
XFILLER_0_41 VPWR VGND VPWR VGND sky130_ef_sc_hd__decap_12
XFILLER_46_370 VPWR VGND VPWR VGND sky130_ef_sc_hd__decap_12
XFILLER_53_318 VGND VGND VPWR VPWR sky130_fd_sc_hd__decap_8
XTAP_TAPCELL_ROW_64_814 VGND VPWR sky130_fd_sc_hd__tapvpwrvgnd_1
XFILLER_0_85 VPWR VGND VPWR VGND sky130_ef_sc_hd__decap_12
X_2994_ systolic_unit_0.U_01.acc_1\[15\] systolic_unit_0.U_01.acc_0\[15\] net139 VGND
+ VGND VPWR VPWR _0947_ sky130_fd_sc_hd__mux2_1
XFILLER_21_248 VGND VGND VPWR VPWR sky130_fd_sc_hd__fill_1
XFILLER_9_83 VGND VGND VPWR VPWR sky130_fd_sc_hd__fill_2
X_3615_ systolic_unit_0.U_11.acc_1\[9\] systolic_unit_0.U_11.acc_0\[9\] net147 VGND
+ VGND VPWR VPWR _1504_ sky130_fd_sc_hd__mux2_1
X_3546_ net192 net179 _1423_ _1433_ VGND VGND VPWR VPWR _1435_ sky130_fd_sc_hd__a31o_1
X_3477_ net134 _1386_ VGND VGND VPWR VPWR _1387_ sky130_fd_sc_hd__nand2_1
X_2428_ _2123_ _2125_ _2126_ VGND VGND VPWR VPWR _2127_ sky130_fd_sc_hd__nand3_1
XFILLER_84_421 VPWR VGND VPWR VGND sky130_ef_sc_hd__decap_12
XFILLER_69_473 VGND VGND VPWR VPWR sky130_fd_sc_hd__fill_2
X_2359_ _2055_ _2057_ _2054_ VGND VGND VPWR VPWR _2058_ sky130_fd_sc_hd__a21o_1
X_4029_ net241 VGND VGND VPWR VPWR _0010_ sky130_fd_sc_hd__inv_2
XFILLER_71_137 VGND VGND VPWR VPWR sky130_fd_sc_hd__decap_6
XFILLER_60_46 VGND VGND VPWR VPWR sky130_fd_sc_hd__decap_6
XFILLER_4_469 VGND VGND VPWR VPWR sky130_fd_sc_hd__decap_6
XFILLER_79_237 VPWR VGND VPWR VGND sky130_ef_sc_hd__decap_12
XFILLER_87_281 VPWR VGND VPWR VGND sky130_ef_sc_hd__decap_12
XTAP_TAPCELL_ROW_78_939 VGND VPWR sky130_fd_sc_hd__tapvpwrvgnd_1
XFILLER_75_487 VPWR VGND VPWR VGND sky130_ef_sc_hd__decap_12
XFILLER_35_307 VPWR VGND VPWR VGND sky130_ef_sc_hd__decap_12
XFILLER_70_170 VGND VGND VPWR VPWR sky130_fd_sc_hd__fill_1
XTAP_TAPCELL_ROW_33_519 VGND VPWR sky130_fd_sc_hd__tapvpwrvgnd_1
XFILLER_79_6 VGND VGND VPWR VPWR sky130_fd_sc_hd__fill_1
XFILLER_11_281 VPWR VGND VPWR VGND sky130_ef_sc_hd__decap_12
XFILLER_7_274 VGND VGND VPWR VPWR sky130_fd_sc_hd__decap_3
X_3400_ net163 net116 _1320_ VGND VGND VPWR VPWR _1321_ sky130_fd_sc_hd__nand3_1
X_4380_ clknet_leaf_3_clk _0353_ _0104_ VGND VGND VPWR VPWR systolic_unit_0.U_00.acc_1\[0\]
+ sky130_fd_sc_hd__dfrtp_1
X_3331_ _1190_ _1250_ _1251_ VGND VGND VPWR VPWR _1252_ sky130_fd_sc_hd__and3_1
X_3262_ _1141_ _1142_ _1143_ VGND VGND VPWR VPWR _1183_ sky130_fd_sc_hd__a21oi_1
X_2213_ _1907_ _1911_ _1905_ VGND VGND VPWR VPWR _1912_ sky130_fd_sc_hd__o21ai_1
X_3193_ _1111_ _1112_ _1110_ VGND VGND VPWR VPWR _1114_ sky130_fd_sc_hd__a21bo_1
X_2144_ systolic_unit_0.out_acc_0_r1\[12\] systolic_unit_0.out_acc_1_r1\[12\] net143
+ VGND VGND VPWR VPWR _1872_ sky130_fd_sc_hd__mux2_1
XFILLER_93_251 VGND VGND VPWR VPWR sky130_fd_sc_hd__fill_1
XFILLER_81_413 VGND VGND VPWR VPWR sky130_fd_sc_hd__fill_1
XTAP_TAPCELL_ROW_49_663 VGND VPWR sky130_fd_sc_hd__tapvpwrvgnd_1
XFILLER_66_465 VGND VGND VPWR VPWR sky130_fd_sc_hd__decap_4
XFILLER_93_295 VGND VGND VPWR VPWR sky130_fd_sc_hd__fill_2
XFILLER_81_446 VGND VGND VPWR VPWR sky130_fd_sc_hd__fill_2
XFILLER_66_498 VPWR VGND VPWR VGND sky130_ef_sc_hd__decap_12
XFILLER_61_181 VGND VGND VPWR VPWR sky130_fd_sc_hd__fill_2
X_2977_ _0927_ _0928_ VGND VGND VPWR VPWR _0930_ sky130_fd_sc_hd__nand2_1
XFILLER_30_27 VGND VGND VPWR VPWR sky130_fd_sc_hd__fill_1
XFILLER_1_417 VPWR VGND VPWR VGND sky130_ef_sc_hd__decap_12
X_3529_ systolic_unit_0.U_10.acc_1\[1\] net76 net83 systolic_unit_0.U_00.acc_1\[1\]
+ VGND VGND VPWR VPWR _1420_ sky130_fd_sc_hd__a22o_1
XPHY_EDGE_ROW_55_Left_149 VGND VGND VPWR VPWR sky130_fd_sc_hd__decap_3
XFILLER_76_229 VGND VGND VPWR VPWR sky130_fd_sc_hd__decap_4
XFILLER_69_281 VGND VGND VPWR VPWR sky130_fd_sc_hd__decap_8
XTAP_TAPCELL_ROW_4_244 VGND VPWR sky130_fd_sc_hd__tapvpwrvgnd_1
XFILLER_84_251 VGND VGND VPWR VPWR sky130_fd_sc_hd__fill_1
XFILLER_72_413 VGND VGND VPWR VPWR sky130_fd_sc_hd__decap_6
XFILLER_84_295 VGND VGND VPWR VPWR sky130_fd_sc_hd__fill_1
XFILLER_55_57 VGND VGND VPWR VPWR sky130_fd_sc_hd__decap_4
XTAP_TAPCELL_ROW_83_986 VGND VPWR sky130_fd_sc_hd__tapvpwrvgnd_1
XFILLER_72_468 VGND VGND VPWR VPWR sky130_fd_sc_hd__decap_8
XFILLER_72_457 VGND VGND VPWR VPWR sky130_fd_sc_hd__decap_6
XFILLER_25_351 VGND VGND VPWR VPWR sky130_fd_sc_hd__fill_2
XFILLER_25_373 VPWR VGND VPWR VGND sky130_ef_sc_hd__decap_12
XPHY_EDGE_ROW_64_Left_158 VGND VGND VPWR VPWR sky130_fd_sc_hd__decap_3
XFILLER_9_517 VPWR VGND VPWR VGND sky130_ef_sc_hd__decap_12
XFILLER_40_365 VPWR VGND VPWR VGND sky130_ef_sc_hd__decap_12
XPHY_EDGE_ROW_73_Left_167 VGND VGND VPWR VPWR sky130_fd_sc_hd__decap_3
XFILLER_20_71 VGND VGND VPWR VPWR sky130_fd_sc_hd__decap_6
XFILLER_0_461 VPWR VGND VPWR VGND sky130_ef_sc_hd__decap_12
XTAP_TAPCELL_ROW_85_1005 VGND VPWR sky130_fd_sc_hd__tapvpwrvgnd_1
Xhold80 net64 VGND VGND VPWR VPWR net355 sky130_fd_sc_hd__dlygate4sd3_1
XFILLER_35_104 VGND VGND VPWR VPWR sky130_fd_sc_hd__decap_8
Xhold91 systolic_unit_0.U_00.acc_1\[11\] VGND VGND VPWR VPWR net366 sky130_fd_sc_hd__dlygate4sd3_1
XFILLER_90_221 VPWR VGND VPWR VGND sky130_ef_sc_hd__decap_12
XPHY_EDGE_ROW_82_Left_176 VGND VGND VPWR VPWR sky130_fd_sc_hd__decap_3
XFILLER_63_435 VGND VGND VPWR VPWR sky130_fd_sc_hd__decap_3
X_2900_ systolic_unit_0.U_00.out_a\[0\] net122 VGND VGND VPWR VPWR _0853_ sky130_fd_sc_hd__nand2_1
XFILLER_16_373 VGND VGND VPWR VPWR sky130_fd_sc_hd__fill_1
XFILLER_16_362 VGND VGND VPWR VPWR sky130_fd_sc_hd__fill_2
XTAP_TAPCELL_ROW_18_368 VGND VPWR sky130_fd_sc_hd__tapvpwrvgnd_1
XFILLER_71_490 VPWR VGND VPWR VGND sky130_ef_sc_hd__decap_12
X_3880_ _1573_ _1611_ VGND VGND VPWR VPWR _1769_ sky130_fd_sc_hd__or2_1
XFILLER_43_181 VGND VGND VPWR VPWR sky130_fd_sc_hd__decap_4
X_2831_ net128 net169 VGND VGND VPWR VPWR _0784_ sky130_fd_sc_hd__nand2_1
X_2762_ _0713_ _0714_ VGND VGND VPWR VPWR _0715_ sky130_fd_sc_hd__nor2_1
X_4501_ clknet_leaf_11_clk net327 _0225_ VGND VGND VPWR VPWR systolic_unit_0.U_01.drain_1
+ sky130_fd_sc_hd__dfrtp_4
XPHY_EDGE_ROW_91_Left_185 VGND VGND VPWR VPWR sky130_fd_sc_hd__decap_3
X_2693_ _0644_ _0645_ VGND VGND VPWR VPWR _0646_ sky130_fd_sc_hd__nand2_1
X_4432_ clknet_leaf_22_clk _0389_ _0156_ VGND VGND VPWR VPWR net51 sky130_fd_sc_hd__dfrtp_1
X_4363_ clknet_leaf_15_clk _0336_ _0087_ VGND VGND VPWR VPWR systolic_unit_0.U_01.acc_1\[15\]
+ sky130_fd_sc_hd__dfrtp_1
X_3314_ systolic_unit_0.U_00.out_b\[2\] net111 _1233_ _1231_ VGND VGND VPWR VPWR _1235_
+ sky130_fd_sc_hd__a31oi_1
X_4294_ clknet_leaf_11_clk _0275_ _0018_ VGND VGND VPWR VPWR systolic_unit_0.U_11.acc_0\[2\]
+ sky130_fd_sc_hd__dfrtp_1
X_3245_ _1164_ _1165_ VGND VGND VPWR VPWR _1166_ sky130_fd_sc_hd__nor2_1
XFILLER_39_443 VGND VGND VPWR VPWR sky130_fd_sc_hd__fill_1
X_3176_ systolic_unit_0.U_10.acc_1\[8\] systolic_unit_0.U_10.acc_0\[8\] net133 VGND
+ VGND VPWR VPWR _1097_ sky130_fd_sc_hd__mux2_1
XTAP_TAPCELL_ROW_1_214 VGND VPWR sky130_fd_sc_hd__tapvpwrvgnd_1
XFILLER_66_273 VPWR VGND VPWR VGND sky130_ef_sc_hd__decap_12
XFILLER_25_27 VPWR VGND VPWR VGND sky130_ef_sc_hd__decap_12
XFILLER_22_332 VGND VGND VPWR VPWR sky130_fd_sc_hd__fill_1
XFILLER_22_365 VGND VGND VPWR VPWR sky130_fd_sc_hd__decap_6
XFILLER_22_398 VGND VGND VPWR VPWR sky130_fd_sc_hd__fill_1
XFILLER_1_225 VPWR VGND VPWR VGND sky130_ef_sc_hd__decap_12
XFILLER_77_505 VPWR VGND VPWR VGND sky130_ef_sc_hd__decap_12
XFILLER_17_137 VGND VGND VPWR VPWR sky130_fd_sc_hd__fill_2
XFILLER_17_104 VGND VGND VPWR VPWR sky130_fd_sc_hd__decap_8
XFILLER_66_89 VGND VGND VPWR VPWR sky130_fd_sc_hd__fill_1
XFILLER_45_457 VGND VGND VPWR VPWR sky130_fd_sc_hd__decap_3
XFILLER_45_479 VPWR VGND VPWR VGND sky130_ef_sc_hd__decap_12
XTAP_TAPCELL_ROW_43_614 VGND VPWR sky130_fd_sc_hd__tapvpwrvgnd_1
XFILLER_82_77 VGND VGND VPWR VPWR sky130_fd_sc_hd__decap_6
XFILLER_15_60 VPWR VGND VPWR VGND sky130_ef_sc_hd__decap_12
XFILLER_5_553 VGND VGND VPWR VPWR sky130_fd_sc_hd__fill_1
XTAP_TAPCELL_ROW_91_1064 VGND VPWR sky130_fd_sc_hd__tapvpwrvgnd_1
Xoutput70 net70 VGND VGND VPWR VPWR D_c_flat[9] sky130_fd_sc_hd__buf_2
XFILLER_68_516 VPWR VGND VPWR VGND sky130_ef_sc_hd__decap_12
X_3030_ _0918_ _0970_ VGND VGND VPWR VPWR _0971_ sky130_fd_sc_hd__and2_1
XFILLER_48_273 VGND VGND VPWR VPWR sky130_fd_sc_hd__decap_4
XFILLER_63_210 VGND VGND VPWR VPWR sky130_fd_sc_hd__fill_1
XFILLER_91_541 VPWR VGND VPWR VGND sky130_ef_sc_hd__decap_12
XFILLER_16_192 VGND VGND VPWR VPWR sky130_fd_sc_hd__decap_4
X_3932_ systolic_unit_0.U_01.acc_0\[6\] net75 net82 systolic_unit_0.U_11.acc_0\[6\]
+ VGND VGND VPWR VPWR _1812_ sky130_fd_sc_hd__a22o_1
XFILLER_31_140 VGND VGND VPWR VPWR sky130_fd_sc_hd__decap_6
XFILLER_31_151 VPWR VGND VPWR VGND sky130_ef_sc_hd__decap_12
X_3863_ _1734_ _1738_ VGND VGND VPWR VPWR _1752_ sky130_fd_sc_hd__xnor2_1
X_2814_ _0761_ _0765_ VGND VGND VPWR VPWR _0767_ sky130_fd_sc_hd__xnor2_1
X_3794_ _1681_ _1682_ VGND VGND VPWR VPWR _1683_ sky130_fd_sc_hd__and2b_1
X_2745_ _0696_ _0697_ VGND VGND VPWR VPWR _0698_ sky130_fd_sc_hd__nor2_1
X_2676_ _0613_ _0617_ _0627_ VGND VGND VPWR VPWR _0629_ sky130_fd_sc_hd__or3_1
X_4415_ clknet_leaf_1_clk _0380_ _0139_ VGND VGND VPWR VPWR systolic_unit_0.U_00.acc_0\[11\]
+ sky130_fd_sc_hd__dfrtp_1
X_4346_ clknet_leaf_26_clk net104 _0070_ VGND VGND VPWR VPWR systolic_unit_0.U_10.out_a\[6\]
+ sky130_fd_sc_hd__dfrtp_2
XFILLER_86_357 VGND VGND VPWR VPWR sky130_fd_sc_hd__decap_6
X_4277_ clknet_leaf_16_clk _0258_ _0013_ VGND VGND VPWR VPWR systolic_unit_0.U_11.acc_1\[13\]
+ sky130_fd_sc_hd__dfrtp_1
X_3228_ _1146_ _1148_ VGND VGND VPWR VPWR _1149_ sky130_fd_sc_hd__nand2b_1
X_3159_ _1079_ _1064_ VGND VGND VPWR VPWR _1080_ sky130_fd_sc_hd__and2b_1
XFILLER_39_273 VGND VGND VPWR VPWR sky130_fd_sc_hd__fill_1
XTAP_TAPCELL_ROW_57_739 VGND VPWR sky130_fd_sc_hd__tapvpwrvgnd_1
XFILLER_27_446 VGND VGND VPWR VPWR sky130_fd_sc_hd__fill_2
XFILLER_54_265 VPWR VGND VPWR VGND sky130_ef_sc_hd__decap_12
XTAP_TAPCELL_ROW_12_319 VGND VPWR sky130_fd_sc_hd__tapvpwrvgnd_1
XFILLER_10_357 VGND VGND VPWR VPWR sky130_fd_sc_hd__fill_1
XTAP_TAPCELL_ROW_20_396 VGND VPWR sky130_fd_sc_hd__tapvpwrvgnd_1
XFILLER_2_501 VPWR VGND VPWR VGND sky130_ef_sc_hd__decap_12
XFILLER_7_3 VPWR VGND VPWR VGND sky130_ef_sc_hd__decap_12
XFILLER_2_545 VGND VGND VPWR VPWR sky130_fd_sc_hd__decap_8
XFILLER_77_55 VGND VGND VPWR VPWR sky130_fd_sc_hd__fill_1
XFILLER_73_541 VPWR VGND VPWR VGND sky130_ef_sc_hd__decap_12
XTAP_TAPCELL_ROW_28_463 VGND VPWR sky130_fd_sc_hd__tapvpwrvgnd_1
Xclkbuf_leaf_25_clk clknet_2_1__leaf_clk VGND VGND VPWR VPWR clknet_leaf_25_clk sky130_fd_sc_hd__clkbuf_8
XFILLER_33_449 VGND VGND VPWR VPWR sky130_fd_sc_hd__decap_3
XFILLER_13_151 VGND VGND VPWR VPWR sky130_fd_sc_hd__decap_4
XFILLER_13_184 VGND VGND VPWR VPWR sky130_fd_sc_hd__fill_2
XFILLER_41_471 VGND VGND VPWR VPWR sky130_fd_sc_hd__fill_2
Xrebuffer3 systolic_unit_0.U_11.switch VGND VGND VPWR VPWR net278 sky130_fd_sc_hd__dlygate4sd1_1
X_2530_ _0509_ _0514_ VGND VGND VPWR VPWR _0515_ sky130_fd_sc_hd__and2b_1
X_2461_ _0437_ _0439_ _0444_ _0445_ VGND VGND VPWR VPWR _0446_ sky130_fd_sc_hd__o211ai_1
X_4200_ net231 VGND VGND VPWR VPWR _0181_ sky130_fd_sc_hd__inv_2
X_2392_ _2088_ _2089_ _2083_ VGND VGND VPWR VPWR _2091_ sky130_fd_sc_hd__a21bo_1
X_4131_ net232 VGND VGND VPWR VPWR _0112_ sky130_fd_sc_hd__inv_2
XFILLER_83_305 VPWR VGND VPWR VGND sky130_ef_sc_hd__decap_12
X_4062_ net223 VGND VGND VPWR VPWR _0043_ sky130_fd_sc_hd__inv_2
XFILLER_83_327 VGND VGND VPWR VPWR sky130_fd_sc_hd__decap_8
X_3013_ _0934_ _0958_ VGND VGND VPWR VPWR _0961_ sky130_fd_sc_hd__xnor2_1
XFILLER_36_221 VPWR VGND VPWR VGND sky130_ef_sc_hd__decap_12
XFILLER_24_449 VPWR VGND VPWR VGND sky130_ef_sc_hd__decap_12
Xclkbuf_leaf_16_clk clknet_2_3__leaf_clk VGND VGND VPWR VPWR clknet_leaf_16_clk sky130_fd_sc_hd__clkbuf_8
XFILLER_51_279 VGND VGND VPWR VPWR sky130_fd_sc_hd__fill_1
X_3915_ net431 _1785_ _1788_ net403 _1799_ VGND VGND VPWR VPWR _0284_ sky130_fd_sc_hd__o221a_1
XTAP_TAPCELL_ROW_62_786 VGND VPWR sky130_fd_sc_hd__tapvpwrvgnd_1
X_3846_ _1691_ _1692_ VGND VGND VPWR VPWR _1735_ sky130_fd_sc_hd__xor2_1
X_3777_ _1657_ _1663_ VGND VGND VPWR VPWR _1666_ sky130_fd_sc_hd__xor2_1
X_2728_ net172 net169 net120 net119 VGND VGND VPWR VPWR _0681_ sky130_fd_sc_hd__and4_1
X_2659_ _0606_ _0607_ VGND VGND VPWR VPWR _0612_ sky130_fd_sc_hd__or2_1
Xfanout112 systolic_unit_0.U_10.in_a\[2\] VGND VGND VPWR VPWR net112 sky130_fd_sc_hd__clkbuf_2
Xfanout101 net102 VGND VGND VPWR VPWR net101 sky130_fd_sc_hd__buf_2
XFILLER_59_302 VPWR VGND VPWR VGND sky130_ef_sc_hd__decap_12
Xfanout123 systolic_unit_0.U_01.in_b\[4\] VGND VGND VPWR VPWR net123 sky130_fd_sc_hd__buf_1
XFILLER_86_121 VPWR VGND VPWR VGND sky130_ef_sc_hd__decap_12
Xfanout156 systolic_unit_0.U_00.out_b\[4\] VGND VGND VPWR VPWR net156 sky130_fd_sc_hd__clkbuf_2
X_4329_ clknet_leaf_29_clk _0310_ _0053_ VGND VGND VPWR VPWR systolic_unit_0.U_10.acc_0\[5\]
+ sky130_fd_sc_hd__dfrtp_1
Xfanout134 net135 VGND VGND VPWR VPWR net134 sky130_fd_sc_hd__buf_2
Xfanout145 net146 VGND VGND VPWR VPWR net145 sky130_fd_sc_hd__buf_2
XFILLER_86_165 VPWR VGND VPWR VGND sky130_ef_sc_hd__decap_12
Xfanout167 net168 VGND VGND VPWR VPWR net167 sky130_fd_sc_hd__buf_2
Xfanout178 systolic_unit_0.U_01.out_b\[7\] VGND VGND VPWR VPWR net178 sky130_fd_sc_hd__buf_2
XFILLER_47_519 VGND VGND VPWR VPWR sky130_fd_sc_hd__fill_2
Xfanout189 systolic_unit_0.U_01.out_b\[0\] VGND VGND VPWR VPWR net189 sky130_fd_sc_hd__buf_2
XFILLER_47_47 VGND VGND VPWR VPWR sky130_fd_sc_hd__decap_8
XFILLER_15_405 VPWR VGND VPWR VGND sky130_ef_sc_hd__decap_12
XFILLER_70_533 VPWR VGND VPWR VGND sky130_ef_sc_hd__decap_12
XFILLER_15_449 VPWR VGND VPWR VGND sky130_ef_sc_hd__decap_12
XFILLER_30_419 VGND VGND VPWR VPWR sky130_fd_sc_hd__fill_1
XFILLER_23_471 VPWR VGND VPWR VGND sky130_ef_sc_hd__decap_12
XFILLER_12_83 VGND VGND VPWR VPWR sky130_fd_sc_hd__fill_1
XFILLER_88_65 VPWR VGND VPWR VGND sky130_ef_sc_hd__decap_12
XFILLER_18_276 VGND VGND VPWR VPWR sky130_fd_sc_hd__decap_4
XFILLER_73_393 VGND VGND VPWR VPWR sky130_fd_sc_hd__decap_4
XFILLER_33_235 VGND VGND VPWR VPWR sky130_fd_sc_hd__decap_8
X_3700_ _1585_ _1588_ VGND VGND VPWR VPWR _1589_ sky130_fd_sc_hd__xnor2_1
X_3631_ _1517_ _1518_ VGND VGND VPWR VPWR _1520_ sky130_fd_sc_hd__xnor2_1
X_3562_ net194 systolic_unit_0.U_01.out_b\[5\] _1422_ VGND VGND VPWR VPWR _1451_ sky130_fd_sc_hd__and3_1
X_2513_ _0490_ _0497_ VGND VGND VPWR VPWR _0498_ sky130_fd_sc_hd__and2_1
X_3493_ net164 net116 _1320_ VGND VGND VPWR VPWR _1399_ sky130_fd_sc_hd__a21o_1
XFILLER_88_419 VGND VGND VPWR VPWR sky130_fd_sc_hd__fill_1
Xclkbuf_leaf_5_clk clknet_2_0__leaf_clk VGND VGND VPWR VPWR clknet_leaf_5_clk sky130_fd_sc_hd__clkbuf_8
X_2444_ _2127_ _0419_ _0428_ VGND VGND VPWR VPWR _0429_ sky130_fd_sc_hd__and3_1
X_2375_ _2069_ _2070_ _2062_ _2064_ VGND VGND VPWR VPWR _2074_ sky130_fd_sc_hd__o211a_1
X_4114_ net246 VGND VGND VPWR VPWR _0095_ sky130_fd_sc_hd__inv_2
XFILLER_29_508 VPWR VGND VPWR VGND sky130_ef_sc_hd__decap_12
XFILLER_56_305 VGND VGND VPWR VPWR sky130_fd_sc_hd__decap_3
XFILLER_83_113 VPWR VGND VPWR VGND sky130_ef_sc_hd__decap_12
XFILLER_68_165 VGND VGND VPWR VPWR sky130_fd_sc_hd__decap_8
XTAP_TAPCELL_ROW_67_834 VGND VPWR sky130_fd_sc_hd__tapvpwrvgnd_1
X_4045_ net241 VGND VGND VPWR VPWR _0026_ sky130_fd_sc_hd__inv_2
XTAP_TAPCELL_ROW_39_569 VGND VPWR sky130_fd_sc_hd__tapvpwrvgnd_1
XFILLER_12_419 VGND VGND VPWR VPWR sky130_fd_sc_hd__fill_1
XTAP_TAPCELL_ROW_22_414 VGND VPWR sky130_fd_sc_hd__tapvpwrvgnd_1
X_3829_ _1704_ _1716_ VGND VGND VPWR VPWR _1718_ sky130_fd_sc_hd__nand2_1
XTAP_TAPCELL_ROW_30_491 VGND VPWR sky130_fd_sc_hd__tapvpwrvgnd_1
XFILLER_55_393 VGND VGND VPWR VPWR sky130_fd_sc_hd__fill_2
XFILLER_70_363 VGND VGND VPWR VPWR sky130_fd_sc_hd__fill_1
XFILLER_15_279 VGND VGND VPWR VPWR sky130_fd_sc_hd__fill_1
XFILLER_30_205 VGND VGND VPWR VPWR sky130_fd_sc_hd__decap_8
XFILLER_90_77 VGND VGND VPWR VPWR sky130_fd_sc_hd__decap_6
XFILLER_11_441 VGND VGND VPWR VPWR sky130_fd_sc_hd__decap_6
XFILLER_11_485 VPWR VGND VPWR VGND sky130_ef_sc_hd__decap_12
XFILLER_78_452 VGND VGND VPWR VPWR sky130_fd_sc_hd__fill_1
X_2160_ systolic_unit_0.out_acc_0_r1\[4\] systolic_unit_0.out_acc_1_r1\[4\] net143
+ VGND VGND VPWR VPWR _1880_ sky130_fd_sc_hd__mux2_1
XFILLER_65_113 VGND VGND VPWR VPWR sky130_fd_sc_hd__decap_8
XFILLER_93_433 VPWR VGND VPWR VGND sky130_ef_sc_hd__decap_12
XTAP_TAPCELL_ROW_88_1036 VGND VPWR sky130_fd_sc_hd__tapvpwrvgnd_1
XFILLER_19_541 VPWR VGND VPWR VGND sky130_ef_sc_hd__decap_12
XFILLER_93_477 VPWR VGND VPWR VGND sky130_ef_sc_hd__decap_12
XFILLER_0_53 VGND VGND VPWR VPWR sky130_fd_sc_hd__decap_3
XFILLER_34_533 VPWR VGND VPWR VGND sky130_ef_sc_hd__decap_12
XTAP_TAPCELL_ROW_36_539 VGND VPWR sky130_fd_sc_hd__tapvpwrvgnd_1
XFILLER_46_382 VGND VGND VPWR VPWR sky130_fd_sc_hd__decap_8
XFILLER_0_97 VPWR VGND VPWR VGND sky130_ef_sc_hd__decap_12
XTAP_TAPCELL_ROW_72_881 VGND VPWR sky130_fd_sc_hd__tapvpwrvgnd_1
X_2993_ _0601_ _0608_ _0605_ VGND VGND VPWR VPWR _0946_ sky130_fd_sc_hd__a21oi_1
XFILLER_9_51 VGND VGND VPWR VPWR sky130_fd_sc_hd__decap_4
X_3614_ net187 net191 _1502_ VGND VGND VPWR VPWR _1503_ sky130_fd_sc_hd__and3_1
X_3545_ net192 net179 _1423_ _1433_ VGND VGND VPWR VPWR _1434_ sky130_fd_sc_hd__and4_1
XFILLER_0_109 VGND VGND VPWR VPWR sky130_fd_sc_hd__decap_3
X_3476_ _1325_ _1385_ VGND VGND VPWR VPWR _1386_ sky130_fd_sc_hd__or2_1
X_2427_ _2081_ _2117_ _2122_ VGND VGND VPWR VPWR _2126_ sky130_fd_sc_hd__a21o_1
X_2358_ systolic_unit_0.U_00.acc_1\[7\] systolic_unit_0.U_00.acc_0\[7\] net208 VGND
+ VGND VPWR VPWR _2057_ sky130_fd_sc_hd__mux2_1
XFILLER_84_433 VPWR VGND VPWR VGND sky130_ef_sc_hd__decap_12
X_2289_ _1969_ _1981_ _1986_ VGND VGND VPWR VPWR _1988_ sky130_fd_sc_hd__a21o_1
XFILLER_84_477 VPWR VGND VPWR VGND sky130_ef_sc_hd__decap_12
X_4028_ net248 VGND VGND VPWR VPWR _0009_ sky130_fd_sc_hd__inv_2
XFILLER_25_511 VPWR VGND VPWR VGND sky130_ef_sc_hd__decap_12
XFILLER_44_15 VGND VGND VPWR VPWR sky130_fd_sc_hd__decap_8
XFILLER_79_205 VPWR VGND VPWR VGND sky130_ef_sc_hd__decap_12
XFILLER_79_249 VPWR VGND VPWR VGND sky130_ef_sc_hd__decap_12
XTAP_TAPCELL_ROW_7_264 VGND VPWR sky130_fd_sc_hd__tapvpwrvgnd_1
XFILLER_47_113 VPWR VGND VPWR VGND sky130_ef_sc_hd__decap_12
XFILLER_87_293 VGND VGND VPWR VPWR sky130_fd_sc_hd__decap_8
XFILLER_85_55 VGND VGND VPWR VPWR sky130_fd_sc_hd__fill_1
XFILLER_35_319 VGND VGND VPWR VPWR sky130_fd_sc_hd__decap_8
XFILLER_75_499 VGND VGND VPWR VPWR sky130_fd_sc_hd__decap_4
XFILLER_16_533 VPWR VGND VPWR VGND sky130_ef_sc_hd__decap_12
XFILLER_16_511 VPWR VGND VPWR VGND sky130_ef_sc_hd__decap_12
XFILLER_11_293 VGND VGND VPWR VPWR sky130_fd_sc_hd__fill_1
XFILLER_11_260 VGND VGND VPWR VPWR sky130_fd_sc_hd__decap_4
X_3330_ _1222_ _1224_ VGND VGND VPWR VPWR _1251_ sky130_fd_sc_hd__nand2_1
X_3261_ _1168_ _1171_ VGND VGND VPWR VPWR _1182_ sky130_fd_sc_hd__nand2_1
X_2212_ _1908_ _1909_ _1910_ VGND VGND VPWR VPWR _1911_ sky130_fd_sc_hd__and3_1
X_3192_ _1110_ _1111_ _1112_ VGND VGND VPWR VPWR _1113_ sky130_fd_sc_hd__nand3_1
XFILLER_22_3 VPWR VGND VPWR VGND sky130_ef_sc_hd__decap_12
XFILLER_93_230 VGND VGND VPWR VPWR sky130_fd_sc_hd__decap_4
X_2143_ net358 _1871_ net90 VGND VGND VPWR VPWR _0414_ sky130_fd_sc_hd__mux2_1
XFILLER_66_477 VGND VGND VPWR VPWR sky130_fd_sc_hd__fill_2
XTAP_TAPCELL_ROW_49_664 VGND VPWR sky130_fd_sc_hd__tapvpwrvgnd_1
XFILLER_19_393 VPWR VGND VPWR VGND sky130_ef_sc_hd__decap_12
XFILLER_34_352 VPWR VGND VPWR VGND sky130_ef_sc_hd__decap_12
XFILLER_61_160 VGND VGND VPWR VPWR sky130_fd_sc_hd__fill_1
XFILLER_14_29 VPWR VGND VPWR VGND sky130_ef_sc_hd__decap_12
X_2976_ _0927_ _0928_ VGND VGND VPWR VPWR _0929_ sky130_fd_sc_hd__nor2_1
XFILLER_1_429 VPWR VGND VPWR VGND sky130_ef_sc_hd__decap_12
X_3528_ net320 _1403_ _1405_ systolic_unit_0.U_00.acc_1\[2\] _1419_ VGND VGND VPWR
+ VPWR _0291_ sky130_fd_sc_hd__a221o_1
X_3459_ _1371_ _1373_ net132 VGND VGND VPWR VPWR _0314_ sky130_fd_sc_hd__mux2_1
XFILLER_29_124 VPWR VGND VPWR VGND sky130_ef_sc_hd__decap_12
XFILLER_55_69 VGND VGND VPWR VPWR sky130_fd_sc_hd__decap_4
XFILLER_44_149 VPWR VGND VPWR VGND sky130_ef_sc_hd__decap_12
XTAP_TAPCELL_ROW_83_987 VGND VPWR sky130_fd_sc_hd__tapvpwrvgnd_1
XFILLER_13_503 VGND VGND VPWR VPWR sky130_fd_sc_hd__fill_1
XFILLER_25_385 VGND VGND VPWR VPWR sky130_fd_sc_hd__fill_1
XFILLER_40_300 VGND VGND VPWR VPWR sky130_fd_sc_hd__decap_8
XFILLER_40_322 VGND VGND VPWR VPWR sky130_fd_sc_hd__decap_8
XFILLER_71_57 VGND VGND VPWR VPWR sky130_fd_sc_hd__decap_3
XFILLER_9_529 VPWR VGND VPWR VGND sky130_ef_sc_hd__decap_12
XFILLER_40_377 VPWR VGND VPWR VGND sky130_ef_sc_hd__decap_12
XFILLER_4_212 VPWR VGND VPWR VGND sky130_ef_sc_hd__decap_12
XFILLER_4_278 VGND VGND VPWR VPWR sky130_fd_sc_hd__fill_1
XFILLER_0_473 VGND VGND VPWR VPWR sky130_fd_sc_hd__decap_3
XFILLER_67_208 VPWR VGND VPWR VGND sky130_ef_sc_hd__decap_12
Xhold70 net41 VGND VGND VPWR VPWR net345 sky130_fd_sc_hd__dlygate4sd3_1
Xhold81 systolic_unit_0.U_00.acc_0\[14\] VGND VGND VPWR VPWR net356 sky130_fd_sc_hd__dlygate4sd3_1
XFILLER_48_477 VGND VGND VPWR VPWR sky130_fd_sc_hd__decap_4
Xhold92 systolic_unit_0.U_01.acc_1\[11\] VGND VGND VPWR VPWR net367 sky130_fd_sc_hd__dlygate4sd3_1
XTAP_TAPCELL_ROW_85_1006 VGND VPWR sky130_fd_sc_hd__tapvpwrvgnd_1
XFILLER_75_296 VGND VGND VPWR VPWR sky130_fd_sc_hd__decap_4
XTAP_TAPCELL_ROW_46_634 VGND VPWR sky130_fd_sc_hd__tapvpwrvgnd_1
XFILLER_90_233 VPWR VGND VPWR VGND sky130_ef_sc_hd__decap_12
XTAP_TAPCELL_ROW_18_369 VGND VPWR sky130_fd_sc_hd__tapvpwrvgnd_1
X_2830_ net130 net168 _0781_ VGND VGND VPWR VPWR _0783_ sky130_fd_sc_hd__and3_1
XFILLER_16_396 VPWR VGND VPWR VGND sky130_ef_sc_hd__decap_12
X_2761_ net170 net122 _0711_ _0712_ VGND VGND VPWR VPWR _0714_ sky130_fd_sc_hd__o2bb2a_1
X_2692_ _0637_ _0643_ VGND VGND VPWR VPWR _0645_ sky130_fd_sc_hd__or2_1
X_4500_ clknet_leaf_3_clk net297 _0224_ VGND VGND VPWR VPWR systolic_unit_0.out_acc_0_r1\[15\]
+ sky130_fd_sc_hd__dfrtp_1
XFILLER_6_41 VPWR VGND VPWR VGND sky130_ef_sc_hd__decap_12
XANTENNA_1 _1897_ VGND VGND VPWR VPWR sky130_fd_sc_hd__diode_2
X_4431_ clknet_leaf_16_clk _0388_ _0155_ VGND VGND VPWR VPWR net49 sky130_fd_sc_hd__dfrtp_1
XFILLER_6_85 VGND VGND VPWR VPWR sky130_fd_sc_hd__decap_8
X_4362_ clknet_leaf_15_clk _0335_ _0086_ VGND VGND VPWR VPWR systolic_unit_0.U_01.acc_1\[14\]
+ sky130_fd_sc_hd__dfrtp_1
X_3313_ _1231_ _1233_ VGND VGND VPWR VPWR _1234_ sky130_fd_sc_hd__and2b_1
X_4293_ clknet_leaf_18_clk net382 _0017_ VGND VGND VPWR VPWR systolic_unit_0.U_11.acc_0\[1\]
+ sky130_fd_sc_hd__dfrtp_1
X_3244_ _1122_ _1124_ _1162_ VGND VGND VPWR VPWR _1165_ sky130_fd_sc_hd__o21a_1
XTAP_TAPCELL_ROW_1_215 VGND VPWR sky130_fd_sc_hd__tapvpwrvgnd_1
X_3175_ systolic_unit_0.U_10.acc_1\[9\] systolic_unit_0.U_10.acc_0\[9\] net132 VGND
+ VGND VPWR VPWR _1096_ sky130_fd_sc_hd__mux2_1
XFILLER_81_233 VGND VGND VPWR VPWR sky130_fd_sc_hd__decap_3
XFILLER_25_39 VPWR VGND VPWR VGND sky130_ef_sc_hd__decap_12
XFILLER_34_160 VGND VGND VPWR VPWR sky130_fd_sc_hd__fill_1
XFILLER_41_108 VGND VGND VPWR VPWR sky130_fd_sc_hd__decap_4
XTAP_TAPCELL_ROW_80_957 VGND VPWR sky130_fd_sc_hd__tapvpwrvgnd_1
XFILLER_41_27 VPWR VGND VPWR VGND sky130_ef_sc_hd__decap_12
X_2959_ systolic_unit_0.U_01.acc_1\[0\] systolic_unit_0.U_01.acc_0\[0\] net140 VGND
+ VGND VPWR VPWR _0912_ sky130_fd_sc_hd__mux2_1
XFILLER_89_344 VGND VGND VPWR VPWR sky130_fd_sc_hd__fill_1
XFILLER_1_237 VPWR VGND VPWR VGND sky130_ef_sc_hd__decap_12
XFILLER_77_517 VPWR VGND VPWR VGND sky130_ef_sc_hd__decap_12
XFILLER_66_13 VGND VGND VPWR VPWR sky130_fd_sc_hd__fill_1
XFILLER_72_244 VGND VGND VPWR VPWR sky130_fd_sc_hd__decap_8
XFILLER_45_447 VGND VGND VPWR VPWR sky130_fd_sc_hd__fill_1
XFILLER_72_288 VGND VGND VPWR VPWR sky130_fd_sc_hd__decap_4
XFILLER_72_299 VGND VGND VPWR VPWR sky130_fd_sc_hd__decap_8
XFILLER_25_182 VGND VGND VPWR VPWR sky130_fd_sc_hd__decap_4
XFILLER_15_72 VPWR VGND VPWR VGND sky130_ef_sc_hd__decap_12
XFILLER_40_141 VGND VGND VPWR VPWR sky130_fd_sc_hd__decap_8
XFILLER_9_337 VPWR VGND VPWR VGND sky130_ef_sc_hd__decap_12
Xoutput60 net60 VGND VGND VPWR VPWR D_c_flat[29] sky130_fd_sc_hd__buf_2
XTAP_TAPCELL_ROW_91_1065 VGND VPWR sky130_fd_sc_hd__tapvpwrvgnd_1
XFILLER_68_528 VGND VGND VPWR VPWR sky130_fd_sc_hd__decap_4
Xoutput71 net71 VGND VGND VPWR VPWR systolic_busy sky130_fd_sc_hd__buf_2
XFILLER_0_281 VGND VGND VPWR VPWR sky130_fd_sc_hd__fill_2
XFILLER_91_553 VGND VGND VPWR VPWR sky130_fd_sc_hd__fill_1
XFILLER_63_233 VGND VGND VPWR VPWR sky130_fd_sc_hd__fill_2
X_3931_ _1757_ _1810_ VGND VGND VPWR VPWR _1811_ sky130_fd_sc_hd__nor2_1
X_3862_ _1720_ _1750_ VGND VGND VPWR VPWR _1751_ sky130_fd_sc_hd__nor2_1
X_2813_ _0761_ _0765_ VGND VGND VPWR VPWR _0766_ sky130_fd_sc_hd__nand2b_1
XFILLER_31_163 VGND VGND VPWR VPWR sky130_fd_sc_hd__decap_4
X_3793_ net201 net186 net183 net202 VGND VGND VPWR VPWR _1682_ sky130_fd_sc_hd__a22o_1
X_2744_ _0664_ _0693_ _0695_ VGND VGND VPWR VPWR _0697_ sky130_fd_sc_hd__and3_1
X_2675_ _0617_ _0627_ _0613_ VGND VGND VPWR VPWR _0628_ sky130_fd_sc_hd__o21ai_1
X_4414_ clknet_leaf_6_clk _0379_ _0138_ VGND VGND VPWR VPWR systolic_unit_0.U_00.acc_0\[10\]
+ sky130_fd_sc_hd__dfrtp_1
X_4345_ clknet_leaf_26_clk net328 _0069_ VGND VGND VPWR VPWR systolic_unit_0.U_10.out_a\[5\]
+ sky130_fd_sc_hd__dfrtp_1
X_4276_ clknet_leaf_16_clk _0257_ _0012_ VGND VGND VPWR VPWR systolic_unit_0.U_11.acc_1\[12\]
+ sky130_fd_sc_hd__dfrtp_1
X_3227_ _1098_ _1147_ VGND VGND VPWR VPWR _1148_ sky130_fd_sc_hd__and2_1
X_3158_ _1071_ _1078_ VGND VGND VPWR VPWR _1079_ sky130_fd_sc_hd__and2b_1
XFILLER_82_553 VGND VGND VPWR VPWR sky130_fd_sc_hd__fill_1
XFILLER_82_531 VGND VGND VPWR VPWR sky130_fd_sc_hd__fill_1
X_3089_ _1005_ _1009_ VGND VGND VPWR VPWR _1010_ sky130_fd_sc_hd__nand2_1
XFILLER_54_277 VGND VGND VPWR VPWR sky130_fd_sc_hd__decap_3
XFILLER_35_491 VGND VGND VPWR VPWR sky130_fd_sc_hd__fill_2
XFILLER_22_141 VPWR VGND VPWR VGND sky130_ef_sc_hd__decap_12
XFILLER_52_59 VPWR VGND VPWR VGND sky130_ef_sc_hd__decap_12
XFILLER_2_513 VPWR VGND VPWR VGND sky130_ef_sc_hd__decap_12
XFILLER_77_12 VGND VGND VPWR VPWR sky130_fd_sc_hd__decap_4
XFILLER_92_306 VGND VGND VPWR VPWR sky130_fd_sc_hd__fill_2
XFILLER_45_211 VGND VGND VPWR VPWR sky130_fd_sc_hd__decap_6
XFILLER_85_391 VGND VGND VPWR VPWR sky130_fd_sc_hd__fill_1
XFILLER_73_553 VGND VGND VPWR VPWR sky130_fd_sc_hd__fill_1
XFILLER_45_233 VGND VGND VPWR VPWR sky130_fd_sc_hd__fill_1
XTAP_TAPCELL_ROW_28_464 VGND VPWR sky130_fd_sc_hd__tapvpwrvgnd_1
Xrebuffer4 net278 VGND VGND VPWR VPWR net279 sky130_fd_sc_hd__buf_2
X_2460_ _0442_ _0443_ _0440_ VGND VGND VPWR VPWR _0445_ sky130_fd_sc_hd__a21o_1
X_4130_ net232 VGND VGND VPWR VPWR _0111_ sky130_fd_sc_hd__inv_2
X_2391_ _2083_ _2088_ _2089_ VGND VGND VPWR VPWR _2090_ sky130_fd_sc_hd__nand3_1
XFILLER_68_358 VGND VGND VPWR VPWR sky130_fd_sc_hd__decap_6
X_4061_ net225 VGND VGND VPWR VPWR _0042_ sky130_fd_sc_hd__inv_2
XFILLER_83_317 VGND VGND VPWR VPWR sky130_fd_sc_hd__decap_4
X_3012_ net393 net85 _0960_ net139 VGND VGND VPWR VPWR _0348_ sky130_fd_sc_hd__a22o_1
XFILLER_36_233 VGND VGND VPWR VPWR sky130_fd_sc_hd__fill_2
XFILLER_64_553 VGND VGND VPWR VPWR sky130_fd_sc_hd__fill_1
X_3914_ net98 _1798_ VGND VGND VPWR VPWR _1799_ sky130_fd_sc_hd__or2_1
XTAP_TAPCELL_ROW_62_787 VGND VPWR sky130_fd_sc_hd__tapvpwrvgnd_1
XFILLER_22_29 VGND VGND VPWR VPWR sky130_fd_sc_hd__fill_2
X_3845_ _1720_ _1733_ VGND VGND VPWR VPWR _1734_ sky130_fd_sc_hd__nor2_1
X_3776_ _1647_ _1649_ VGND VGND VPWR VPWR _1665_ sky130_fd_sc_hd__xnor2_1
X_2727_ _0667_ _0679_ VGND VGND VPWR VPWR _0680_ sky130_fd_sc_hd__nand2_1
X_2658_ _0601_ _0605_ _0610_ VGND VGND VPWR VPWR _0611_ sky130_fd_sc_hd__o21a_1
Xfanout113 net114 VGND VGND VPWR VPWR net113 sky130_fd_sc_hd__clkbuf_2
Xfanout102 systolic_unit_0.U_10.in_a\[7\] VGND VGND VPWR VPWR net102 sky130_fd_sc_hd__clkbuf_2
X_2589_ _0535_ _0569_ VGND VGND VPWR VPWR _0570_ sky130_fd_sc_hd__nand2_1
Xfanout124 net125 VGND VGND VPWR VPWR net124 sky130_fd_sc_hd__buf_2
X_4328_ clknet_leaf_29_clk _0309_ _0052_ VGND VGND VPWR VPWR systolic_unit_0.U_10.acc_0\[4\]
+ sky130_fd_sc_hd__dfrtp_1
Xfanout135 net136 VGND VGND VPWR VPWR net135 sky130_fd_sc_hd__buf_4
Xfanout146 net151 VGND VGND VPWR VPWR net146 sky130_fd_sc_hd__clkbuf_4
XFILLER_59_314 VPWR VGND VPWR VGND sky130_ef_sc_hd__decap_12
XFILLER_86_133 VGND VGND VPWR VPWR sky130_fd_sc_hd__decap_6
Xfanout168 systolic_unit_0.U_00.out_a\[5\] VGND VGND VPWR VPWR net168 sky130_fd_sc_hd__clkbuf_2
X_4259_ net231 VGND VGND VPWR VPWR _0240_ sky130_fd_sc_hd__inv_2
Xfanout157 systolic_unit_0.U_00.out_b\[4\] VGND VGND VPWR VPWR net157 sky130_fd_sc_hd__buf_1
Xfanout179 systolic_unit_0.U_01.out_b\[7\] VGND VGND VPWR VPWR net179 sky130_fd_sc_hd__dlymetal6s2s_1
XFILLER_86_177 VPWR VGND VPWR VGND sky130_ef_sc_hd__decap_12
XFILLER_27_211 VGND VGND VPWR VPWR sky130_fd_sc_hd__fill_1
XFILLER_67_391 VGND VGND VPWR VPWR sky130_fd_sc_hd__fill_1
XFILLER_70_501 VPWR VGND VPWR VGND sky130_ef_sc_hd__decap_12
XFILLER_15_417 VPWR VGND VPWR VGND sky130_ef_sc_hd__decap_12
XFILLER_70_545 VGND VGND VPWR VPWR sky130_fd_sc_hd__decap_8
XFILLER_23_461 VGND VGND VPWR VPWR sky130_fd_sc_hd__fill_2
XFILLER_23_483 VPWR VGND VPWR VGND sky130_ef_sc_hd__decap_12
XFILLER_88_77 VGND VGND VPWR VPWR sky130_fd_sc_hd__decap_6
XFILLER_2_365 VGND VGND VPWR VPWR sky130_fd_sc_hd__fill_1
XFILLER_77_111 VGND VGND VPWR VPWR sky130_fd_sc_hd__fill_1
XFILLER_77_166 VGND VGND VPWR VPWR sky130_fd_sc_hd__fill_2
XFILLER_37_81 VGND VGND VPWR VPWR sky130_fd_sc_hd__decap_8
XFILLER_33_225 VGND VGND VPWR VPWR sky130_fd_sc_hd__fill_1
X_3630_ _1517_ _1518_ VGND VGND VPWR VPWR _1519_ sky130_fd_sc_hd__and2b_1
X_3561_ _1429_ _1430_ VGND VGND VPWR VPWR _1450_ sky130_fd_sc_hd__xnor2_1
XFILLER_52_3 VGND VGND VPWR VPWR sky130_fd_sc_hd__decap_8
X_2512_ _0491_ _0493_ _0496_ VGND VGND VPWR VPWR _0497_ sky130_fd_sc_hd__a21o_1
X_3492_ _1396_ _1398_ net137 VGND VGND VPWR VPWR _0306_ sky130_fd_sc_hd__mux2_1
X_2443_ _0425_ _0426_ _0422_ VGND VGND VPWR VPWR _0428_ sky130_fd_sc_hd__a21bo_1
X_2374_ _2033_ _2072_ _2034_ VGND VGND VPWR VPWR _2073_ sky130_fd_sc_hd__o21a_1
X_4113_ net245 VGND VGND VPWR VPWR _0094_ sky130_fd_sc_hd__inv_2
XFILLER_68_177 VPWR VGND VPWR VGND sky130_ef_sc_hd__decap_12
XTAP_TAPCELL_ROW_67_835 VGND VPWR sky130_fd_sc_hd__tapvpwrvgnd_1
XFILLER_83_125 VPWR VGND VPWR VGND sky130_ef_sc_hd__decap_12
X_4044_ net248 VGND VGND VPWR VPWR _0025_ sky130_fd_sc_hd__inv_2
XFILLER_83_169 VPWR VGND VPWR VGND sky130_ef_sc_hd__decap_12
XFILLER_24_214 VGND VGND VPWR VPWR sky130_fd_sc_hd__fill_2
XFILLER_24_258 VGND VGND VPWR VPWR sky130_fd_sc_hd__decap_6
XTAP_TAPCELL_ROW_22_415 VGND VPWR sky130_fd_sc_hd__tapvpwrvgnd_1
X_3828_ _1704_ _1716_ VGND VGND VPWR VPWR _1717_ sky130_fd_sc_hd__nor2_1
X_3759_ net185 net199 net183 net200 VGND VGND VPWR VPWR _1648_ sky130_fd_sc_hd__a22o_1
XFILLER_59_111 VGND VGND VPWR VPWR sky130_fd_sc_hd__fill_1
XFILLER_87_453 VGND VGND VPWR VPWR sky130_fd_sc_hd__fill_1
XFILLER_58_69 VPWR VGND VPWR VGND sky130_ef_sc_hd__decap_12
XFILLER_59_177 VGND VGND VPWR VPWR sky130_fd_sc_hd__decap_4
XFILLER_28_531 VGND VGND VPWR VPWR sky130_fd_sc_hd__fill_1
XFILLER_28_553 VGND VGND VPWR VPWR sky130_fd_sc_hd__fill_1
XFILLER_15_225 VGND VGND VPWR VPWR sky130_fd_sc_hd__decap_8
XFILLER_70_331 VPWR VGND VPWR VGND sky130_ef_sc_hd__decap_12
XPHY_EDGE_ROW_4_Left_98 VGND VGND VPWR VPWR sky130_fd_sc_hd__decap_3
XFILLER_11_497 VGND VGND VPWR VPWR sky130_fd_sc_hd__decap_6
XFILLER_23_94 VGND VGND VPWR VPWR sky130_fd_sc_hd__fill_1
XFILLER_2_173 VGND VGND VPWR VPWR sky130_fd_sc_hd__fill_1
XFILLER_93_445 VGND VGND VPWR VPWR sky130_fd_sc_hd__decap_3
XTAP_TAPCELL_ROW_88_1037 VGND VPWR sky130_fd_sc_hd__tapvpwrvgnd_1
XFILLER_93_489 VPWR VGND VPWR VGND sky130_ef_sc_hd__decap_12
XFILLER_19_553 VGND VGND VPWR VPWR sky130_fd_sc_hd__fill_1
XFILLER_53_309 VGND VGND VPWR VPWR sky130_fd_sc_hd__decap_4
XTAP_TAPCELL_ROW_64_805 VGND VPWR sky130_fd_sc_hd__tapvpwrvgnd_1
XFILLER_65_169 VGND VGND VPWR VPWR sky130_fd_sc_hd__decap_4
XFILLER_34_545 VGND VGND VPWR VPWR sky130_fd_sc_hd__decap_8
XTAP_TAPCELL_ROW_72_882 VGND VPWR sky130_fd_sc_hd__tapvpwrvgnd_1
X_2992_ _0632_ _0663_ _0942_ _0631_ _0611_ VGND VGND VPWR VPWR _0945_ sky130_fd_sc_hd__a32o_1
X_3613_ systolic_unit_0.U_11.acc_1\[8\] systolic_unit_0.U_11.acc_0\[8\] net150 VGND
+ VGND VPWR VPWR _1502_ sky130_fd_sc_hd__mux2_1
X_3544_ systolic_unit_0.U_11.acc_1\[14\] systolic_unit_0.U_11.acc_0\[14\] net148 VGND
+ VGND VPWR VPWR _1433_ sky130_fd_sc_hd__mux2_1
X_3475_ _1299_ _1302_ _1324_ VGND VGND VPWR VPWR _1385_ sky130_fd_sc_hd__a21oi_1
XFILLER_69_420 VGND VGND VPWR VPWR sky130_fd_sc_hd__decap_6
X_2426_ _2110_ _2124_ VGND VGND VPWR VPWR _2125_ sky130_fd_sc_hd__nor2_1
XFILLER_28_17 VGND VGND VPWR VPWR sky130_fd_sc_hd__decap_8
X_2357_ _2054_ _2055_ VGND VGND VPWR VPWR _2056_ sky130_fd_sc_hd__nand2b_1
XFILLER_84_445 VPWR VGND VPWR VGND sky130_ef_sc_hd__decap_12
X_2288_ _1969_ _1981_ _1986_ VGND VGND VPWR VPWR _1987_ sky130_fd_sc_hd__nand3_1
XFILLER_84_489 VPWR VGND VPWR VGND sky130_ef_sc_hd__decap_12
X_4027_ net241 VGND VGND VPWR VPWR _0008_ sky130_fd_sc_hd__inv_2
XFILLER_25_523 VPWR VGND VPWR VGND sky130_ef_sc_hd__decap_12
XFILLER_37_361 VPWR VGND VPWR VGND sky130_ef_sc_hd__decap_12
XFILLER_52_331 VPWR VGND VPWR VGND sky130_ef_sc_hd__decap_12
XFILLER_40_504 VGND VGND VPWR VPWR sky130_fd_sc_hd__decap_6
XFILLER_12_228 VGND VGND VPWR VPWR sky130_fd_sc_hd__fill_1
XFILLER_20_250 VGND VGND VPWR VPWR sky130_fd_sc_hd__fill_2
XFILLER_60_26 VGND VGND VPWR VPWR sky130_fd_sc_hd__fill_2
XFILLER_69_57 VPWR VGND VPWR VGND sky130_ef_sc_hd__decap_12
XFILLER_79_217 VGND VGND VPWR VPWR sky130_fd_sc_hd__decap_6
XTAP_TAPCELL_ROW_7_265 VGND VPWR sky130_fd_sc_hd__tapvpwrvgnd_1
XFILLER_47_125 VPWR VGND VPWR VGND sky130_ef_sc_hd__decap_12
XFILLER_16_523 VGND VGND VPWR VPWR sky130_fd_sc_hd__decap_8
XFILLER_18_83 VGND VGND VPWR VPWR sky130_fd_sc_hd__fill_1
XFILLER_28_361 VGND VGND VPWR VPWR sky130_fd_sc_hd__decap_3
XFILLER_16_545 VGND VGND VPWR VPWR sky130_fd_sc_hd__decap_8
XFILLER_55_180 VGND VGND VPWR VPWR sky130_fd_sc_hd__decap_3
XTAP_TAPCELL_ROW_41_587 VGND VPWR sky130_fd_sc_hd__tapvpwrvgnd_1
X_3260_ _1178_ _1179_ _1177_ VGND VGND VPWR VPWR _1181_ sky130_fd_sc_hd__a21boi_1
X_3191_ _1069_ _1104_ _1109_ VGND VGND VPWR VPWR _1112_ sky130_fd_sc_hd__a21o_1
X_2211_ systolic_unit_0.U_00.acc_1\[12\] systolic_unit_0.U_00.acc_0\[12\] net209 VGND
+ VGND VPWR VPWR _1910_ sky130_fd_sc_hd__mux2_1
XTAP_TAPCELL_ROW_77_930 VGND VPWR sky130_fd_sc_hd__tapvpwrvgnd_1
XFILLER_15_3 VPWR VGND VPWR VGND sky130_ef_sc_hd__decap_12
X_2142_ systolic_unit_0.out_acc_0_r1\[13\] systolic_unit_0.out_acc_1_r1\[13\] net279
+ VGND VGND VPWR VPWR _1871_ sky130_fd_sc_hd__mux2_1
XFILLER_93_253 VPWR VGND VPWR VGND sky130_ef_sc_hd__decap_12
XFILLER_26_309 VPWR VGND VPWR VGND sky130_ef_sc_hd__decap_12
XTAP_TAPCELL_ROW_49_665 VGND VPWR sky130_fd_sc_hd__tapvpwrvgnd_1
XFILLER_19_372 VGND VGND VPWR VPWR sky130_fd_sc_hd__fill_2
XFILLER_34_331 VGND VGND VPWR VPWR sky130_fd_sc_hd__decap_8
XFILLER_14_19 VGND VGND VPWR VPWR sky130_fd_sc_hd__decap_8
XTAP_TAPCELL_ROW_32_510 VGND VPWR sky130_fd_sc_hd__tapvpwrvgnd_1
X_2975_ _0821_ _0841_ _0840_ VGND VGND VPWR VPWR _0928_ sky130_fd_sc_hd__a21oi_1
XFILLER_30_29 VGND VGND VPWR VPWR sky130_fd_sc_hd__decap_4
X_3527_ net137 _1393_ VGND VGND VPWR VPWR _1419_ sky130_fd_sc_hd__nor2_1
X_3458_ _1201_ _1372_ VGND VGND VPWR VPWR _1373_ sky130_fd_sc_hd__xnor2_1
X_3389_ _1304_ _1308_ _1309_ _1290_ VGND VGND VPWR VPWR _1310_ sky130_fd_sc_hd__o211a_1
X_2409_ systolic_unit_0.U_00.acc_1\[5\] systolic_unit_0.U_00.acc_0\[5\] net211 VGND
+ VGND VPWR VPWR _2108_ sky130_fd_sc_hd__mux2_1
XTAP_TAPCELL_ROW_4_235 VGND VPWR sky130_fd_sc_hd__tapvpwrvgnd_1
XFILLER_29_136 VGND VGND VPWR VPWR sky130_fd_sc_hd__fill_1
XFILLER_57_423 VGND VGND VPWR VPWR sky130_fd_sc_hd__decap_8
XFILLER_84_253 VGND VGND VPWR VPWR sky130_fd_sc_hd__decap_8
XFILLER_29_158 VGND VGND VPWR VPWR sky130_fd_sc_hd__decap_8
XFILLER_29_169 VPWR VGND VPWR VGND sky130_ef_sc_hd__decap_12
XFILLER_55_48 VGND VGND VPWR VPWR sky130_fd_sc_hd__decap_8
XTAP_TAPCELL_ROW_83_988 VGND VPWR sky130_fd_sc_hd__tapvpwrvgnd_1
XFILLER_52_194 VGND VGND VPWR VPWR sky130_fd_sc_hd__fill_2
XFILLER_40_389 VGND VGND VPWR VPWR sky130_fd_sc_hd__decap_8
XFILLER_4_224 VPWR VGND VPWR VGND sky130_ef_sc_hd__decap_12
XTAP_TAPCELL_ROW_74_900 VGND VPWR sky130_fd_sc_hd__tapvpwrvgnd_1
Xhold82 net61 VGND VGND VPWR VPWR net357 sky130_fd_sc_hd__dlygate4sd3_1
Xhold71 net65 VGND VGND VPWR VPWR net346 sky130_fd_sc_hd__dlygate4sd3_1
Xhold60 net51 VGND VGND VPWR VPWR net335 sky130_fd_sc_hd__dlygate4sd3_1
XTAP_TAPCELL_ROW_85_1007 VGND VPWR sky130_fd_sc_hd__tapvpwrvgnd_1
Xhold93 systolic_unit_0.U_00.acc_0\[8\] VGND VGND VPWR VPWR net368 sky130_fd_sc_hd__dlygate4sd3_1
XFILLER_63_415 VPWR VGND VPWR VGND sky130_ef_sc_hd__decap_12
XFILLER_90_245 VGND VGND VPWR VPWR sky130_fd_sc_hd__decap_3
XTAP_TAPCELL_ROW_46_635 VGND VPWR sky130_fd_sc_hd__tapvpwrvgnd_1
X_2760_ _0711_ _0712_ net170 net122 VGND VGND VPWR VPWR _0713_ sky130_fd_sc_hd__and4bb_1
X_2691_ _0637_ _0643_ VGND VGND VPWR VPWR _0644_ sky130_fd_sc_hd__nand2_1
XFILLER_61_91 VGND VGND VPWR VPWR sky130_fd_sc_hd__decap_8
X_4430_ clknet_leaf_11_clk _0387_ _0154_ VGND VGND VPWR VPWR net48 sky130_fd_sc_hd__dfrtp_1
XANTENNA_2 net3 VGND VGND VPWR VPWR sky130_fd_sc_hd__diode_2
XFILLER_6_53 VPWR VGND VPWR VGND sky130_ef_sc_hd__decap_12
X_4361_ clknet_leaf_15_clk _0334_ _0085_ VGND VGND VPWR VPWR systolic_unit_0.U_01.acc_1\[13\]
+ sky130_fd_sc_hd__dfrtp_1
X_3312_ net113 net159 net156 net115 VGND VGND VPWR VPWR _1233_ sky130_fd_sc_hd__a22o_1
X_4292_ clknet_leaf_19_clk _0273_ _0016_ VGND VGND VPWR VPWR systolic_unit_0.U_11.acc_0\[0\]
+ sky130_fd_sc_hd__dfrtp_1
X_3243_ _1163_ VGND VGND VPWR VPWR _1164_ sky130_fd_sc_hd__inv_2
X_3174_ net160 net103 _1093_ _1091_ VGND VGND VPWR VPWR _1095_ sky130_fd_sc_hd__a31o_1
XFILLER_66_253 VPWR VGND VPWR VGND sky130_ef_sc_hd__decap_12
XFILLER_26_106 VPWR VGND VPWR VGND sky130_ef_sc_hd__decap_12
XFILLER_81_223 VGND VGND VPWR VPWR sky130_fd_sc_hd__fill_1
XFILLER_54_459 VGND VGND VPWR VPWR sky130_fd_sc_hd__fill_1
XFILLER_62_470 VGND VGND VPWR VPWR sky130_fd_sc_hd__decap_6
XTAP_TAPCELL_ROW_80_958 VGND VPWR sky130_fd_sc_hd__tapvpwrvgnd_1
XFILLER_22_312 VPWR VGND VPWR VGND sky130_ef_sc_hd__decap_12
XFILLER_62_492 VGND VGND VPWR VPWR sky130_fd_sc_hd__decap_6
XFILLER_41_39 VGND VGND VPWR VPWR sky130_fd_sc_hd__decap_4
X_2958_ _0896_ _0898_ VGND VGND VPWR VPWR _0911_ sky130_fd_sc_hd__xnor2_1
X_2889_ _0821_ _0841_ VGND VGND VPWR VPWR _0842_ sky130_fd_sc_hd__xnor2_1
XFILLER_1_249 VGND VGND VPWR VPWR sky130_fd_sc_hd__decap_8
XFILLER_77_529 VPWR VGND VPWR VGND sky130_ef_sc_hd__decap_12
XFILLER_72_278 VGND VGND VPWR VPWR sky130_fd_sc_hd__decap_4
XFILLER_60_418 VGND VGND VPWR VPWR sky130_fd_sc_hd__fill_2
XFILLER_25_161 VGND VGND VPWR VPWR sky130_fd_sc_hd__decap_6
XFILLER_15_84 VGND VGND VPWR VPWR sky130_fd_sc_hd__decap_4
XFILLER_9_349 VGND VGND VPWR VPWR sky130_fd_sc_hd__decap_4
XTAP_TAPCELL_ROW_51_682 VGND VPWR sky130_fd_sc_hd__tapvpwrvgnd_1
XFILLER_40_197 VGND VGND VPWR VPWR sky130_fd_sc_hd__decap_3
Xoutput50 net50 VGND VGND VPWR VPWR D_c_flat[1] sky130_fd_sc_hd__buf_2
Xoutput61 net61 VGND VGND VPWR VPWR D_c_flat[2] sky130_fd_sc_hd__buf_2
XTAP_TAPCELL_ROW_91_1066 VGND VPWR sky130_fd_sc_hd__tapvpwrvgnd_1
Xoutput72 net72 VGND VGND VPWR VPWR systolic_free sky130_fd_sc_hd__buf_2
XTAP_TAPCELL_ROW_59_760 VGND VPWR sky130_fd_sc_hd__tapvpwrvgnd_1
X_3930_ _1753_ _1756_ VGND VGND VPWR VPWR _1810_ sky130_fd_sc_hd__and2_1
XFILLER_63_278 VGND VGND VPWR VPWR sky130_fd_sc_hd__fill_2
XFILLER_16_161 VGND VGND VPWR VPWR sky130_fd_sc_hd__fill_2
X_3861_ _1741_ _1749_ VGND VGND VPWR VPWR _1750_ sky130_fd_sc_hd__or2_1
X_2812_ _0762_ _0764_ VGND VGND VPWR VPWR _0765_ sky130_fd_sc_hd__xnor2_1
XFILLER_82_3 VPWR VGND VPWR VGND sky130_ef_sc_hd__decap_12
X_3792_ net202 net201 net186 net183 VGND VGND VPWR VPWR _1681_ sky130_fd_sc_hd__and4_1
X_2743_ _0693_ _0695_ _0664_ VGND VGND VPWR VPWR _0696_ sky130_fd_sc_hd__a21oi_1
X_2674_ _0618_ _0626_ VGND VGND VPWR VPWR _0627_ sky130_fd_sc_hd__nor2_1
X_4413_ clknet_leaf_1_clk _0378_ _0137_ VGND VGND VPWR VPWR systolic_unit_0.U_00.acc_0\[9\]
+ sky130_fd_sc_hd__dfrtp_1
X_4344_ clknet_leaf_26_clk net108 _0068_ VGND VGND VPWR VPWR systolic_unit_0.U_10.out_a\[4\]
+ sky130_fd_sc_hd__dfrtp_1
X_4275_ clknet_leaf_17_clk _0256_ _0011_ VGND VGND VPWR VPWR systolic_unit_0.U_11.acc_1\[11\]
+ sky130_fd_sc_hd__dfrtp_1
X_3226_ net162 net101 _1097_ VGND VGND VPWR VPWR _1147_ sky130_fd_sc_hd__a21o_1
XFILLER_39_220 VGND VGND VPWR VPWR sky130_fd_sc_hd__decap_4
XPHY_EDGE_ROW_6_Left_100 VGND VGND VPWR VPWR sky130_fd_sc_hd__decap_3
X_3157_ _1071_ _1077_ _1076_ VGND VGND VPWR VPWR _1078_ sky130_fd_sc_hd__or3b_1
X_3088_ _1003_ _1004_ VGND VGND VPWR VPWR _1009_ sky130_fd_sc_hd__or2_1
XFILLER_52_38 VGND VGND VPWR VPWR sky130_fd_sc_hd__decap_6
XFILLER_10_315 VGND VGND VPWR VPWR sky130_fd_sc_hd__fill_1
XFILLER_22_153 VGND VGND VPWR VPWR sky130_fd_sc_hd__decap_4
XFILLER_22_175 VGND VGND VPWR VPWR sky130_fd_sc_hd__decap_6
XFILLER_50_462 VPWR VGND VPWR VGND sky130_ef_sc_hd__decap_12
XFILLER_22_197 VPWR VGND VPWR VGND sky130_ef_sc_hd__decap_12
XTAP_TAPCELL_ROW_20_387 VGND VPWR sky130_fd_sc_hd__tapvpwrvgnd_1
XFILLER_2_525 VGND VGND VPWR VPWR sky130_fd_sc_hd__decap_6
XFILLER_77_57 VPWR VGND VPWR VGND sky130_ef_sc_hd__decap_12
XTAP_TAPCELL_ROW_56_730 VGND VPWR sky130_fd_sc_hd__tapvpwrvgnd_1
XTAP_TAPCELL_ROW_28_465 VGND VPWR sky130_fd_sc_hd__tapvpwrvgnd_1
XFILLER_45_289 VGND VGND VPWR VPWR sky130_fd_sc_hd__decap_3
XFILLER_26_94 VPWR VGND VPWR VGND sky130_ef_sc_hd__decap_12
XFILLER_13_164 VGND VGND VPWR VPWR sky130_fd_sc_hd__decap_4
XFILLER_9_113 VGND VGND VPWR VPWR sky130_fd_sc_hd__decap_6
XTAP_TAPCELL_ROW_11_310 VGND VPWR sky130_fd_sc_hd__tapvpwrvgnd_1
Xrebuffer5 _1276_ VGND VGND VPWR VPWR net280 sky130_fd_sc_hd__dlymetal6s2s_1
X_2390_ _2042_ _2077_ _2082_ VGND VGND VPWR VPWR _2089_ sky130_fd_sc_hd__a21o_1
XPHY_EDGE_ROW_79_Left_173 VGND VGND VPWR VPWR sky130_fd_sc_hd__decap_3
X_4060_ net222 VGND VGND VPWR VPWR _0041_ sky130_fd_sc_hd__inv_2
X_3011_ _0957_ _0959_ VGND VGND VPWR VPWR _0960_ sky130_fd_sc_hd__xnor2_1
XFILLER_17_470 VPWR VGND VPWR VGND sky130_ef_sc_hd__decap_12
X_3913_ _1573_ _1797_ VGND VGND VPWR VPWR _1798_ sky130_fd_sc_hd__xor2_1
XFILLER_32_451 VGND VGND VPWR VPWR sky130_fd_sc_hd__fill_1
XFILLER_51_259 VPWR VGND VPWR VGND sky130_ef_sc_hd__decap_12
XPHY_EDGE_ROW_88_Left_182 VGND VGND VPWR VPWR sky130_fd_sc_hd__decap_3
X_3844_ _1729_ _1731_ _1732_ VGND VGND VPWR VPWR _1733_ sky130_fd_sc_hd__o21ai_1
XTAP_TAPCELL_ROW_62_788 VGND VPWR sky130_fd_sc_hd__tapvpwrvgnd_1
X_3775_ _1657_ _1663_ VGND VGND VPWR VPWR _1664_ sky130_fd_sc_hd__nand2_1
X_2726_ _0676_ _0678_ _0671_ VGND VGND VPWR VPWR _0679_ sky130_fd_sc_hd__a21o_1
X_2657_ _0601_ _0609_ VGND VGND VPWR VPWR _0610_ sky130_fd_sc_hd__nand2_1
Xfanout103 net104 VGND VGND VPWR VPWR net103 sky130_fd_sc_hd__buf_2
X_2588_ _2072_ _0536_ VGND VGND VPWR VPWR _0569_ sky130_fd_sc_hd__nor2_1
Xfanout125 systolic_unit_0.U_01.in_b\[3\] VGND VGND VPWR VPWR net125 sky130_fd_sc_hd__clkbuf_2
Xfanout114 systolic_unit_0.U_10.in_a\[1\] VGND VGND VPWR VPWR net114 sky130_fd_sc_hd__buf_2
X_4327_ clknet_leaf_26_clk _0308_ _0051_ VGND VGND VPWR VPWR systolic_unit_0.U_10.acc_0\[3\]
+ sky130_fd_sc_hd__dfrtp_1
Xfanout136 net142 VGND VGND VPWR VPWR net136 sky130_fd_sc_hd__buf_12
Xfanout147 net149 VGND VGND VPWR VPWR net147 sky130_fd_sc_hd__buf_2
XFILLER_59_326 VGND VGND VPWR VPWR sky130_fd_sc_hd__decap_6
Xfanout169 systolic_unit_0.U_00.out_a\[4\] VGND VGND VPWR VPWR net169 sky130_fd_sc_hd__buf_2
Xfanout158 net159 VGND VGND VPWR VPWR net158 sky130_fd_sc_hd__buf_2
X_4258_ net231 VGND VGND VPWR VPWR _0239_ sky130_fd_sc_hd__inv_2
XFILLER_86_189 VGND VGND VPWR VPWR sky130_fd_sc_hd__decap_6
XFILLER_74_307 VGND VGND VPWR VPWR sky130_fd_sc_hd__fill_1
X_3209_ _1105_ _1107_ _1106_ VGND VGND VPWR VPWR _1130_ sky130_fd_sc_hd__a21o_1
XFILLER_27_223 VGND VGND VPWR VPWR sky130_fd_sc_hd__fill_1
X_4189_ net228 VGND VGND VPWR VPWR _0170_ sky130_fd_sc_hd__inv_2
XFILLER_55_543 VGND VGND VPWR VPWR sky130_fd_sc_hd__decap_3
XFILLER_70_513 VPWR VGND VPWR VGND sky130_ef_sc_hd__decap_12
XFILLER_15_429 VPWR VGND VPWR VGND sky130_ef_sc_hd__decap_12
XTAP_TAPCELL_ROW_25_435 VGND VPWR sky130_fd_sc_hd__tapvpwrvgnd_1
XFILLER_23_495 VGND VGND VPWR VPWR sky130_fd_sc_hd__decap_8
XFILLER_10_156 VPWR VGND VPWR VGND sky130_ef_sc_hd__decap_12
XFILLER_12_85 VPWR VGND VPWR VGND sky130_ef_sc_hd__decap_12
XFILLER_18_234 VGND VGND VPWR VPWR sky130_fd_sc_hd__decap_4
XFILLER_46_521 VGND VGND VPWR VPWR sky130_fd_sc_hd__decap_3
XFILLER_73_362 VGND VGND VPWR VPWR sky130_fd_sc_hd__fill_1
XPHY_EDGE_ROW_16_Right_16 VGND VGND VPWR VPWR sky130_fd_sc_hd__decap_3
XFILLER_53_81 VGND VGND VPWR VPWR sky130_fd_sc_hd__decap_4
XFILLER_41_281 VPWR VGND VPWR VGND sky130_ef_sc_hd__decap_12
XPHY_EDGE_ROW_25_Right_25 VGND VGND VPWR VPWR sky130_fd_sc_hd__decap_3
X_3560_ _1447_ _1448_ VGND VGND VPWR VPWR _1449_ sky130_fd_sc_hd__xnor2_1
X_2511_ _0475_ _0494_ _0495_ VGND VGND VPWR VPWR _0496_ sky130_fd_sc_hd__nor3_1
X_3491_ _1322_ _1397_ VGND VGND VPWR VPWR _1398_ sky130_fd_sc_hd__nor2_1
XFILLER_45_3 VPWR VGND VPWR VGND sky130_ef_sc_hd__decap_12
X_2442_ _0422_ _0425_ _0426_ VGND VGND VPWR VPWR _0427_ sky130_fd_sc_hd__nand3_1
X_2373_ _2035_ _2069_ _2071_ VGND VGND VPWR VPWR _2072_ sky130_fd_sc_hd__nor3_1
X_4112_ net244 VGND VGND VPWR VPWR _0093_ sky130_fd_sc_hd__inv_2
XFILLER_68_189 VGND VGND VPWR VPWR sky130_fd_sc_hd__decap_6
X_4043_ net241 VGND VGND VPWR VPWR _0024_ sky130_fd_sc_hd__inv_2
XFILLER_56_318 VGND VGND VPWR VPWR sky130_fd_sc_hd__decap_4
XFILLER_83_137 VPWR VGND VPWR VGND sky130_ef_sc_hd__decap_12
XPHY_EDGE_ROW_34_Right_34 VGND VGND VPWR VPWR sky130_fd_sc_hd__decap_3
XTAP_TAPCELL_ROW_67_836 VGND VPWR sky130_fd_sc_hd__tapvpwrvgnd_1
XFILLER_91_181 VPWR VGND VPWR VGND sky130_ef_sc_hd__decap_12
XFILLER_24_204 VGND VGND VPWR VPWR sky130_fd_sc_hd__fill_1
XFILLER_64_384 VPWR VGND VPWR VGND sky130_ef_sc_hd__decap_12
XFILLER_20_421 VGND VGND VPWR VPWR sky130_fd_sc_hd__decap_4
XFILLER_20_432 VPWR VGND VPWR VGND sky130_ef_sc_hd__decap_12
XFILLER_32_270 VPWR VGND VPWR VGND sky130_ef_sc_hd__decap_12
X_3827_ _1713_ _1714_ _1711_ VGND VGND VPWR VPWR _1716_ sky130_fd_sc_hd__a21oi_4
XPHY_EDGE_ROW_43_Right_43 VGND VGND VPWR VPWR sky130_fd_sc_hd__decap_3
XFILLER_20_487 VGND VGND VPWR VPWR sky130_fd_sc_hd__fill_1
XTAP_TAPCELL_ROW_30_482 VGND VPWR sky130_fd_sc_hd__tapvpwrvgnd_1
X_3758_ net202 net182 VGND VGND VPWR VPWR _1647_ sky130_fd_sc_hd__nand2_1
X_2709_ _0660_ _0661_ VGND VGND VPWR VPWR _0662_ sky130_fd_sc_hd__and2b_1
X_3689_ systolic_unit_0.U_11.acc_1\[6\] systolic_unit_0.U_11.acc_0\[6\] net146 VGND
+ VGND VPWR VPWR _1578_ sky130_fd_sc_hd__mux2_1
XFILLER_58_15 VPWR VGND VPWR VGND sky130_ef_sc_hd__decap_12
XPHY_EDGE_ROW_52_Right_52 VGND VGND VPWR VPWR sky130_fd_sc_hd__decap_3
XFILLER_74_126 VPWR VGND VPWR VGND sky130_ef_sc_hd__decap_12
XFILLER_74_25 VGND VGND VPWR VPWR sky130_fd_sc_hd__decap_3
XFILLER_43_502 VGND VGND VPWR VPWR sky130_fd_sc_hd__fill_2
XTAP_TAPCELL_ROW_38_560 VGND VPWR sky130_fd_sc_hd__tapvpwrvgnd_1
XFILLER_70_343 VPWR VGND VPWR VGND sky130_ef_sc_hd__decap_12
XFILLER_70_365 VGND VGND VPWR VPWR sky130_fd_sc_hd__fill_1
XFILLER_23_281 VGND VGND VPWR VPWR sky130_fd_sc_hd__decap_3
XPHY_EDGE_ROW_61_Right_61 VGND VGND VPWR VPWR sky130_fd_sc_hd__decap_3
XFILLER_7_447 VGND VGND VPWR VPWR sky130_fd_sc_hd__fill_1
XFILLER_78_421 VGND VGND VPWR VPWR sky130_fd_sc_hd__decap_4
XPHY_EDGE_ROW_70_Right_70 VGND VGND VPWR VPWR sky130_fd_sc_hd__decap_3
XFILLER_2_141 VGND VGND VPWR VPWR sky130_fd_sc_hd__decap_6
XTAP_TAPCELL_ROW_88_1038 VGND VPWR sky130_fd_sc_hd__tapvpwrvgnd_1
XTAP_TAPCELL_ROW_64_806 VGND VPWR sky130_fd_sc_hd__tapvpwrvgnd_1
XFILLER_80_107 VPWR VGND VPWR VGND sky130_ef_sc_hd__decap_12
XFILLER_73_181 VPWR VGND VPWR VGND sky130_ef_sc_hd__decap_12
XFILLER_46_395 VPWR VGND VPWR VGND sky130_ef_sc_hd__decap_12
XTAP_TAPCELL_ROW_72_883 VGND VPWR sky130_fd_sc_hd__tapvpwrvgnd_1
X_2991_ _0632_ _0663_ _0942_ VGND VGND VPWR VPWR _0944_ sky130_fd_sc_hd__and3_1
X_3612_ _1475_ _1500_ VGND VGND VPWR VPWR _1501_ sky130_fd_sc_hd__nor2_1
X_3543_ _1426_ _1431_ VGND VGND VPWR VPWR _1432_ sky130_fd_sc_hd__nand2b_1
X_3474_ _1383_ _1384_ net96 VGND VGND VPWR VPWR _0310_ sky130_fd_sc_hd__mux2_1
X_2425_ net270 net219 net217 net272 VGND VGND VPWR VPWR _2124_ sky130_fd_sc_hd__a22oi_1
X_2356_ net254 net260 net256 net275 VGND VGND VPWR VPWR _2055_ sky130_fd_sc_hd__a22o_1
X_2287_ _1983_ _1984_ _1982_ VGND VGND VPWR VPWR _1986_ sky130_fd_sc_hd__o21bai_1
XFILLER_84_457 VPWR VGND VPWR VGND sky130_ef_sc_hd__decap_12
X_4026_ net246 VGND VGND VPWR VPWR _0007_ sky130_fd_sc_hd__inv_2
XFILLER_25_502 VGND VGND VPWR VPWR sky130_fd_sc_hd__fill_2
XFILLER_37_373 VPWR VGND VPWR VGND sky130_ef_sc_hd__decap_12
XFILLER_25_535 VPWR VGND VPWR VGND sky130_ef_sc_hd__decap_12
XTAP_TAPCELL_ROW_35_530 VGND VPWR sky130_fd_sc_hd__tapvpwrvgnd_1
XFILLER_52_321 VGND VGND VPWR VPWR sky130_fd_sc_hd__fill_1
XFILLER_52_343 VGND VGND VPWR VPWR sky130_fd_sc_hd__decap_6
XFILLER_52_365 VPWR VGND VPWR VGND sky130_ef_sc_hd__decap_12
XFILLER_20_284 VGND VGND VPWR VPWR sky130_fd_sc_hd__fill_2
XFILLER_69_69 VPWR VGND VPWR VGND sky130_ef_sc_hd__decap_12
XTAP_TAPCELL_ROW_7_266 VGND VPWR sky130_fd_sc_hd__tapvpwrvgnd_1
XFILLER_87_273 VGND VGND VPWR VPWR sky130_fd_sc_hd__decap_3
XFILLER_85_57 VPWR VGND VPWR VGND sky130_ef_sc_hd__decap_12
XFILLER_47_137 VGND VGND VPWR VPWR sky130_fd_sc_hd__decap_3
XFILLER_18_95 VPWR VGND VPWR VGND sky130_ef_sc_hd__decap_12
XFILLER_70_195 VGND VGND VPWR VPWR sky130_fd_sc_hd__fill_1
XFILLER_7_222 VGND VGND VPWR VPWR sky130_fd_sc_hd__fill_2
XTAP_TAPCELL_ROW_41_588 VGND VPWR sky130_fd_sc_hd__tapvpwrvgnd_1
XFILLER_3_461 VPWR VGND VPWR VGND sky130_ef_sc_hd__decap_12
X_2210_ net260 net212 net257 net217 VGND VGND VPWR VPWR _1909_ sky130_fd_sc_hd__a22o_1
X_3190_ _1092_ _1094_ VGND VGND VPWR VPWR _1111_ sky130_fd_sc_hd__xnor2_1
XTAP_TAPCELL_ROW_77_931 VGND VPWR sky130_fd_sc_hd__tapvpwrvgnd_1
X_2141_ net332 _1870_ net90 VGND VGND VPWR VPWR _0415_ sky130_fd_sc_hd__mux2_1
XFILLER_93_265 VPWR VGND VPWR VGND sky130_ef_sc_hd__decap_12
XFILLER_81_405 VGND VGND VPWR VPWR sky130_fd_sc_hd__decap_8
XTAP_TAPCELL_ROW_49_666 VGND VPWR sky130_fd_sc_hd__tapvpwrvgnd_1
XFILLER_93_287 VGND VGND VPWR VPWR sky130_fd_sc_hd__decap_8
XFILLER_75_90 VGND VGND VPWR VPWR sky130_fd_sc_hd__decap_8
XFILLER_81_449 VGND VGND VPWR VPWR sky130_fd_sc_hd__fill_2
X_2974_ _0808_ _0809_ VGND VGND VPWR VPWR _0927_ sky130_fd_sc_hd__xnor2_1
XFILLER_34_387 VPWR VGND VPWR VGND sky130_ef_sc_hd__decap_12
XPHY_EDGE_ROW_15_Left_109 VGND VGND VPWR VPWR sky130_fd_sc_hd__decap_3
XFILLER_89_505 VPWR VGND VPWR VGND sky130_ef_sc_hd__decap_12
X_3526_ net321 _1403_ _1405_ net414 _1418_ VGND VGND VPWR VPWR _0292_ sky130_fd_sc_hd__a221o_1
X_3457_ _1333_ _1335_ VGND VGND VPWR VPWR _1372_ sky130_fd_sc_hd__nand2_1
X_3388_ _1287_ _1288_ _1289_ VGND VGND VPWR VPWR _1309_ sky130_fd_sc_hd__a21o_1
X_2408_ _2106_ VGND VGND VPWR VPWR _2107_ sky130_fd_sc_hd__inv_2
XFILLER_84_221 VGND VGND VPWR VPWR sky130_fd_sc_hd__decap_8
X_2339_ net268 net216 _2003_ _2005_ VGND VGND VPWR VPWR _2038_ sky130_fd_sc_hd__a22o_1
XTAP_TAPCELL_ROW_4_236 VGND VPWR sky130_fd_sc_hd__tapvpwrvgnd_1
XPHY_EDGE_ROW_24_Left_118 VGND VGND VPWR VPWR sky130_fd_sc_hd__decap_3
XPHY_EDGE_ROW_2_Right_2 VGND VGND VPWR VPWR sky130_fd_sc_hd__decap_3
XFILLER_29_148 VGND VGND VPWR VPWR sky130_fd_sc_hd__fill_2
XFILLER_57_446 VGND VGND VPWR VPWR sky130_fd_sc_hd__fill_2
X_4009_ matrix_count\[0\] net35 VGND VGND VPWR VPWR _1858_ sky130_fd_sc_hd__nand2_1
XFILLER_25_343 VGND VGND VPWR VPWR sky130_fd_sc_hd__decap_8
XFILLER_37_181 VGND VGND VPWR VPWR sky130_fd_sc_hd__fill_1
XTAP_TAPCELL_ROW_83_989 VGND VPWR sky130_fd_sc_hd__tapvpwrvgnd_1
XFILLER_13_505 VPWR VGND VPWR VGND sky130_ef_sc_hd__decap_12
XFILLER_80_482 VPWR VGND VPWR VGND sky130_ef_sc_hd__decap_12
XPHY_EDGE_ROW_33_Left_127 VGND VGND VPWR VPWR sky130_fd_sc_hd__decap_3
XFILLER_4_236 VGND VGND VPWR VPWR sky130_fd_sc_hd__decap_4
XFILLER_20_41 VGND VGND VPWR VPWR sky130_fd_sc_hd__decap_8
XPHY_EDGE_ROW_42_Left_136 VGND VGND VPWR VPWR sky130_fd_sc_hd__decap_3
Xhold72 net66 VGND VGND VPWR VPWR net347 sky130_fd_sc_hd__dlygate4sd3_1
XFILLER_29_94 VPWR VGND VPWR VGND sky130_ef_sc_hd__decap_12
Xhold61 net55 VGND VGND VPWR VPWR net336 sky130_fd_sc_hd__dlygate4sd3_1
Xhold83 net43 VGND VGND VPWR VPWR net358 sky130_fd_sc_hd__dlygate4sd3_1
XTAP_TAPCELL_ROW_85_1008 VGND VPWR sky130_fd_sc_hd__tapvpwrvgnd_1
XTAP_TAPCELL_ROW_74_901 VGND VPWR sky130_fd_sc_hd__tapvpwrvgnd_1
Xhold94 systolic_unit_0.U_00.acc_0\[0\] VGND VGND VPWR VPWR net369 sky130_fd_sc_hd__dlygate4sd3_1
XFILLER_63_427 VGND VGND VPWR VPWR sky130_fd_sc_hd__decap_8
XTAP_TAPCELL_ROW_46_636 VGND VPWR sky130_fd_sc_hd__tapvpwrvgnd_1
XFILLER_16_365 VGND VGND VPWR VPWR sky130_fd_sc_hd__decap_8
XFILLER_31_302 VPWR VGND VPWR VGND sky130_ef_sc_hd__decap_12
XFILLER_31_346 VGND VGND VPWR VPWR sky130_fd_sc_hd__fill_2
XPHY_EDGE_ROW_51_Left_145 VGND VGND VPWR VPWR sky130_fd_sc_hd__decap_3
XFILLER_8_531 VGND VGND VPWR VPWR sky130_fd_sc_hd__fill_1
X_2690_ _0641_ _0642_ VGND VGND VPWR VPWR _0643_ sky130_fd_sc_hd__and2b_1
XFILLER_8_553 VGND VGND VPWR VPWR sky130_fd_sc_hd__fill_1
XANTENNA_3 net277 VGND VGND VPWR VPWR sky130_fd_sc_hd__diode_2
X_4360_ clknet_leaf_15_clk _0333_ _0084_ VGND VGND VPWR VPWR systolic_unit_0.U_01.acc_1\[12\]
+ sky130_fd_sc_hd__dfrtp_1
XFILLER_6_65 VPWR VGND VPWR VGND sky130_ef_sc_hd__decap_12
X_3311_ systolic_unit_0.U_00.out_b\[2\] net112 VGND VGND VPWR VPWR _1232_ sky130_fd_sc_hd__nand2_1
X_4291_ clknet_leaf_24_clk _0272_ VGND VGND VPWR VPWR row_count\[2\] sky130_fd_sc_hd__dfxtp_1
XPHY_EDGE_ROW_60_Left_154 VGND VGND VPWR VPWR sky130_fd_sc_hd__decap_3
X_3242_ _1122_ _1124_ _1162_ VGND VGND VPWR VPWR _1163_ sky130_fd_sc_hd__or3_1
X_3173_ _1091_ _1093_ VGND VGND VPWR VPWR _1094_ sky130_fd_sc_hd__and2b_1
XFILLER_26_118 VPWR VGND VPWR VGND sky130_ef_sc_hd__decap_12
XFILLER_66_265 VGND VGND VPWR VPWR sky130_fd_sc_hd__fill_1
XFILLER_81_257 VGND VGND VPWR VPWR sky130_fd_sc_hd__fill_2
XTAP_TAPCELL_ROW_80_959 VGND VPWR sky130_fd_sc_hd__tapvpwrvgnd_1
XTAP_TAPCELL_ROW_17_360 VGND VPWR sky130_fd_sc_hd__tapvpwrvgnd_1
XFILLER_22_324 VGND VGND VPWR VPWR sky130_fd_sc_hd__decap_8
XFILLER_34_195 VGND VGND VPWR VPWR sky130_fd_sc_hd__fill_1
X_2957_ _0901_ _0909_ VGND VGND VPWR VPWR _0910_ sky130_fd_sc_hd__nor2_1
X_2888_ _0822_ _0839_ VGND VGND VPWR VPWR _0841_ sky130_fd_sc_hd__xnor2_1
XFILLER_89_324 VGND VGND VPWR VPWR sky130_fd_sc_hd__fill_2
X_4489_ clknet_leaf_30_clk net326 _0213_ VGND VGND VPWR VPWR systolic_unit_0.out_acc_0_r1\[4\]
+ sky130_fd_sc_hd__dfrtp_1
X_3509_ systolic_unit_0.U_10.acc_1\[11\] net76 net83 systolic_unit_0.U_00.acc_1\[11\]
+ VGND VGND VPWR VPWR _1410_ sky130_fd_sc_hd__a22o_1
XFILLER_85_541 VPWR VGND VPWR VGND sky130_ef_sc_hd__decap_12
XFILLER_45_405 VGND VGND VPWR VPWR sky130_fd_sc_hd__fill_2
XFILLER_45_449 VGND VGND VPWR VPWR sky130_fd_sc_hd__decap_8
XTAP_TAPCELL_ROW_43_606 VGND VPWR sky130_fd_sc_hd__tapvpwrvgnd_1
XFILLER_15_96 VGND VGND VPWR VPWR sky130_fd_sc_hd__decap_8
XTAP_TAPCELL_ROW_51_683 VGND VPWR sky130_fd_sc_hd__tapvpwrvgnd_1
XFILLER_21_390 VGND VGND VPWR VPWR sky130_fd_sc_hd__fill_2
Xoutput40 net40 VGND VGND VPWR VPWR D_c_flat[10] sky130_fd_sc_hd__buf_2
Xoutput51 net51 VGND VGND VPWR VPWR D_c_flat[20] sky130_fd_sc_hd__buf_2
XTAP_TAPCELL_ROW_91_1067 VGND VPWR sky130_fd_sc_hd__tapvpwrvgnd_1
Xoutput62 net62 VGND VGND VPWR VPWR D_c_flat[30] sky130_fd_sc_hd__buf_2
XFILLER_0_272 VGND VGND VPWR VPWR sky130_fd_sc_hd__decap_4
XFILLER_0_294 VGND VGND VPWR VPWR sky130_fd_sc_hd__decap_3
XFILLER_48_221 VGND VGND VPWR VPWR sky130_fd_sc_hd__decap_6
XFILLER_36_405 VPWR VGND VPWR VGND sky130_ef_sc_hd__decap_12
XTAP_TAPCELL_ROW_59_761 VGND VPWR sky130_fd_sc_hd__tapvpwrvgnd_1
Xclkbuf_leaf_28_clk clknet_2_1__leaf_clk VGND VGND VPWR VPWR clknet_leaf_28_clk sky130_fd_sc_hd__clkbuf_8
XFILLER_56_70 VGND VGND VPWR VPWR sky130_fd_sc_hd__fill_1
XFILLER_51_408 VGND VGND VPWR VPWR sky130_fd_sc_hd__fill_2
XFILLER_51_419 VGND VGND VPWR VPWR sky130_fd_sc_hd__decap_4
XFILLER_44_482 VGND VGND VPWR VPWR sky130_fd_sc_hd__fill_2
XTAP_TAPCELL_ROW_14_330 VGND VPWR sky130_fd_sc_hd__tapvpwrvgnd_1
X_3860_ _1731_ _1742_ _1748_ VGND VGND VPWR VPWR _1749_ sky130_fd_sc_hd__or3_1
X_2811_ _0721_ _0763_ VGND VGND VPWR VPWR _0764_ sky130_fd_sc_hd__nor2_1
XFILLER_72_91 VGND VGND VPWR VPWR sky130_fd_sc_hd__decap_4
X_3791_ net204 net182 VGND VGND VPWR VPWR _1680_ sky130_fd_sc_hd__nand2_1
X_2742_ _0686_ _0689_ _0693_ _0694_ VGND VGND VPWR VPWR _0695_ sky130_fd_sc_hd__o211ai_2
XFILLER_75_3 VGND VGND VPWR VPWR sky130_fd_sc_hd__fill_1
X_2673_ _0624_ _0625_ VGND VGND VPWR VPWR _0626_ sky130_fd_sc_hd__nand2_1
XFILLER_8_383 VPWR VGND VPWR VGND sky130_ef_sc_hd__decap_12
X_4412_ clknet_leaf_6_clk _0377_ _0136_ VGND VGND VPWR VPWR systolic_unit_0.U_00.acc_0\[8\]
+ sky130_fd_sc_hd__dfrtp_1
X_4343_ clknet_leaf_26_clk net110 _0067_ VGND VGND VPWR VPWR systolic_unit_0.U_10.out_a\[3\]
+ sky130_fd_sc_hd__dfrtp_1
X_4274_ clknet_leaf_22_clk _0255_ _0010_ VGND VGND VPWR VPWR systolic_unit_0.U_11.acc_1\[10\]
+ sky130_fd_sc_hd__dfrtp_1
XFILLER_59_519 VGND VGND VPWR VPWR sky130_fd_sc_hd__decap_3
X_3225_ _1132_ _1134_ VGND VGND VPWR VPWR _1146_ sky130_fd_sc_hd__nor2_1
XFILLER_79_390 VGND VGND VPWR VPWR sky130_fd_sc_hd__fill_2
XFILLER_67_541 VPWR VGND VPWR VGND sky130_ef_sc_hd__decap_12
X_3156_ _1039_ _1065_ _1070_ VGND VGND VPWR VPWR _1077_ sky130_fd_sc_hd__a21oi_1
XFILLER_27_405 VPWR VGND VPWR VGND sky130_ef_sc_hd__decap_12
XFILLER_82_533 VPWR VGND VPWR VGND sky130_ef_sc_hd__decap_12
XFILLER_27_449 VPWR VGND VPWR VGND sky130_ef_sc_hd__decap_12
X_3087_ _1006_ _1007_ VGND VGND VPWR VPWR _1008_ sky130_fd_sc_hd__or2_1
XFILLER_36_29 VPWR VGND VPWR VGND sky130_ef_sc_hd__decap_12
Xclkbuf_leaf_19_clk clknet_2_3__leaf_clk VGND VGND VPWR VPWR clknet_leaf_19_clk sky130_fd_sc_hd__clkbuf_8
XFILLER_50_474 VGND VGND VPWR VPWR sky130_fd_sc_hd__fill_2
X_3989_ net419 _1828_ _1831_ systolic_unit_0.U_01.acc_1\[0\] _1846_ VGND VGND VPWR
+ VPWR _0245_ sky130_fd_sc_hd__o221a_1
XFILLER_6_309 VPWR VGND VPWR VGND sky130_ef_sc_hd__decap_12
XTAP_TAPCELL_ROW_20_388 VGND VPWR sky130_fd_sc_hd__tapvpwrvgnd_1
XFILLER_77_69 VGND VGND VPWR VPWR sky130_fd_sc_hd__decap_3
XFILLER_93_57 VPWR VGND VPWR VGND sky130_ef_sc_hd__decap_12
XTAP_TAPCELL_ROW_56_731 VGND VPWR sky130_fd_sc_hd__tapvpwrvgnd_1
XTAP_TAPCELL_ROW_28_466 VGND VPWR sky130_fd_sc_hd__tapvpwrvgnd_1
XFILLER_45_279 VGND VGND VPWR VPWR sky130_fd_sc_hd__fill_1
XFILLER_60_205 VGND VGND VPWR VPWR sky130_fd_sc_hd__fill_1
XFILLER_60_249 VGND VGND VPWR VPWR sky130_fd_sc_hd__decap_3
XFILLER_3_55 VGND VGND VPWR VPWR sky130_fd_sc_hd__fill_1
X_3010_ _0775_ _0934_ _0776_ VGND VGND VPWR VPWR _0959_ sky130_fd_sc_hd__o21ba_1
XFILLER_64_533 VPWR VGND VPWR VGND sky130_ef_sc_hd__decap_12
XFILLER_91_385 VGND VGND VPWR VPWR sky130_fd_sc_hd__decap_6
XFILLER_17_482 VPWR VGND VPWR VGND sky130_ef_sc_hd__decap_12
XFILLER_24_419 VGND VGND VPWR VPWR sky130_fd_sc_hd__fill_1
X_3912_ _1611_ _1768_ _1610_ VGND VGND VPWR VPWR _1797_ sky130_fd_sc_hd__o21a_1
XFILLER_32_463 VGND VGND VPWR VPWR sky130_fd_sc_hd__fill_1
XFILLER_32_474 VGND VGND VPWR VPWR sky130_fd_sc_hd__fill_2
X_3843_ _1713_ _1715_ VGND VGND VPWR VPWR _1732_ sky130_fd_sc_hd__xnor2_1
XTAP_TAPCELL_ROW_62_789 VGND VPWR sky130_fd_sc_hd__tapvpwrvgnd_1
X_3774_ net187 net198 _1662_ _1660_ VGND VGND VPWR VPWR _1663_ sky130_fd_sc_hd__a31o_1
X_2725_ _0671_ _0677_ VGND VGND VPWR VPWR _0678_ sky130_fd_sc_hd__nor2_1
Xclkbuf_leaf_8_clk clknet_2_2__leaf_clk VGND VGND VPWR VPWR clknet_leaf_8_clk sky130_fd_sc_hd__clkbuf_8
X_2656_ _0605_ _0608_ VGND VGND VPWR VPWR _0609_ sky130_fd_sc_hd__xnor2_1
Xfanout104 systolic_unit_0.U_10.in_a\[6\] VGND VGND VPWR VPWR net104 sky130_fd_sc_hd__clkbuf_2
X_2587_ _2033_ _2034_ VGND VGND VPWR VPWR _0568_ sky130_fd_sc_hd__and2b_1
Xfanout126 net127 VGND VGND VPWR VPWR net126 sky130_fd_sc_hd__buf_2
Xfanout115 net116 VGND VGND VPWR VPWR net115 sky130_fd_sc_hd__buf_2
X_4326_ clknet_leaf_26_clk _0307_ _0050_ VGND VGND VPWR VPWR systolic_unit_0.U_10.acc_0\[2\]
+ sky130_fd_sc_hd__dfrtp_1
Xfanout137 net142 VGND VGND VPWR VPWR net137 sky130_fd_sc_hd__clkbuf_4
X_4257_ net237 VGND VGND VPWR VPWR _0238_ sky130_fd_sc_hd__inv_2
Xfanout159 systolic_unit_0.U_00.out_b\[3\] VGND VGND VPWR VPWR net159 sky130_fd_sc_hd__clkbuf_2
Xfanout148 net149 VGND VGND VPWR VPWR net148 sky130_fd_sc_hd__clkbuf_4
X_3208_ net115 net113 net155 net154 VGND VGND VPWR VPWR _1129_ sky130_fd_sc_hd__and4_1
X_4188_ net224 VGND VGND VPWR VPWR _0169_ sky130_fd_sc_hd__inv_2
X_3139_ _1059_ VGND VGND VPWR VPWR _1060_ sky130_fd_sc_hd__inv_2
XFILLER_82_330 VGND VGND VPWR VPWR sky130_fd_sc_hd__decap_3
XFILLER_70_525 VGND VGND VPWR VPWR sky130_fd_sc_hd__decap_6
XFILLER_27_279 VGND VGND VPWR VPWR sky130_fd_sc_hd__fill_1
XTAP_TAPCELL_ROW_53_701 VGND VPWR sky130_fd_sc_hd__tapvpwrvgnd_1
XTAP_TAPCELL_ROW_25_436 VGND VPWR sky130_fd_sc_hd__tapvpwrvgnd_1
XFILLER_10_168 VGND VGND VPWR VPWR sky130_fd_sc_hd__fill_2
XFILLER_12_97 VGND VGND VPWR VPWR sky130_fd_sc_hd__fill_2
XFILLER_5_3 VPWR VGND VPWR VGND sky130_ef_sc_hd__decap_12
XFILLER_77_113 VPWR VGND VPWR VGND sky130_ef_sc_hd__decap_12
XFILLER_61_503 VGND VGND VPWR VPWR sky130_fd_sc_hd__fill_1
XFILLER_14_485 VPWR VGND VPWR VGND sky130_ef_sc_hd__decap_12
XFILLER_41_293 VPWR VGND VPWR VGND sky130_ef_sc_hd__decap_12
X_3490_ _1308_ _1319_ _1321_ VGND VGND VPWR VPWR _1397_ sky130_fd_sc_hd__o21a_1
X_2510_ net275 net269 _0473_ _0474_ VGND VGND VPWR VPWR _0495_ sky130_fd_sc_hd__o2bb2a_1
X_2441_ _2121_ _0420_ _0421_ VGND VGND VPWR VPWR _0426_ sky130_fd_sc_hd__a21o_1
XFILLER_68_102 VPWR VGND VPWR VGND sky130_ef_sc_hd__decap_12
XFILLER_38_3 VGND VGND VPWR VPWR sky130_fd_sc_hd__decap_3
X_2372_ _2062_ _2064_ _2069_ _2070_ VGND VGND VPWR VPWR _2071_ sky130_fd_sc_hd__a211oi_2
X_4111_ net244 VGND VGND VPWR VPWR _0092_ sky130_fd_sc_hd__inv_2
XFILLER_83_105 VGND VGND VPWR VPWR sky130_fd_sc_hd__decap_6
X_4042_ net246 VGND VGND VPWR VPWR _0023_ sky130_fd_sc_hd__inv_2
XFILLER_49_371 VGND VGND VPWR VPWR sky130_fd_sc_hd__decap_6
XTAP_TAPCELL_ROW_67_837 VGND VPWR sky130_fd_sc_hd__tapvpwrvgnd_1
XFILLER_83_149 VPWR VGND VPWR VGND sky130_ef_sc_hd__decap_12
XFILLER_64_352 VGND VGND VPWR VPWR sky130_fd_sc_hd__fill_1
XFILLER_64_363 VGND VGND VPWR VPWR sky130_fd_sc_hd__fill_1
XFILLER_91_193 VPWR VGND VPWR VGND sky130_ef_sc_hd__decap_12
XFILLER_52_547 VGND VGND VPWR VPWR sky130_fd_sc_hd__decap_3
XFILLER_64_396 VPWR VGND VPWR VGND sky130_ef_sc_hd__decap_12
XTAP_TAPCELL_ROW_22_406 VGND VPWR sky130_fd_sc_hd__tapvpwrvgnd_1
XFILLER_32_282 VPWR VGND VPWR VGND sky130_ef_sc_hd__decap_12
X_3826_ _1711_ _1714_ VGND VGND VPWR VPWR _1715_ sky130_fd_sc_hd__nand2b_1
X_3757_ net200 net185 net198 net183 VGND VGND VPWR VPWR _1646_ sky130_fd_sc_hd__and4_1
X_2708_ _0640_ _0653_ _0655_ VGND VGND VPWR VPWR _0661_ sky130_fd_sc_hd__a21bo_1
XTAP_TAPCELL_ROW_30_483 VGND VPWR sky130_fd_sc_hd__tapvpwrvgnd_1
X_3688_ _1542_ _1543_ VGND VGND VPWR VPWR _1577_ sky130_fd_sc_hd__xnor2_1
X_2639_ systolic_unit_0.U_00.out_a\[6\] net119 VGND VGND VPWR VPWR _0592_ sky130_fd_sc_hd__and2_1
XFILLER_58_27 VGND VGND VPWR VPWR sky130_fd_sc_hd__fill_1
X_4309_ clknet_leaf_28_clk _0290_ _0033_ VGND VGND VPWR VPWR systolic_unit_0.U_10.acc_1\[1\]
+ sky130_fd_sc_hd__dfrtp_1
XFILLER_58_49 VGND VGND VPWR VPWR sky130_fd_sc_hd__decap_3
XFILLER_59_113 VPWR VGND VPWR VGND sky130_ef_sc_hd__decap_12
XFILLER_74_105 VGND VGND VPWR VPWR sky130_fd_sc_hd__decap_3
XFILLER_74_138 VGND VGND VPWR VPWR sky130_fd_sc_hd__fill_2
XFILLER_74_15 VGND VGND VPWR VPWR sky130_fd_sc_hd__decap_3
XFILLER_28_533 VPWR VGND VPWR VGND sky130_ef_sc_hd__decap_12
XFILLER_70_300 VGND VGND VPWR VPWR sky130_fd_sc_hd__decap_8
XFILLER_15_205 VPWR VGND VPWR VGND sky130_ef_sc_hd__decap_12
XTAP_TAPCELL_ROW_38_561 VGND VPWR sky130_fd_sc_hd__tapvpwrvgnd_1
XFILLER_43_525 VGND VGND VPWR VPWR sky130_fd_sc_hd__decap_8
XFILLER_70_377 VPWR VGND VPWR VGND sky130_ef_sc_hd__decap_12
XFILLER_70_355 VGND VGND VPWR VPWR sky130_fd_sc_hd__decap_8
XFILLER_23_293 VGND VGND VPWR VPWR sky130_fd_sc_hd__decap_4
XFILLER_78_411 VGND VGND VPWR VPWR sky130_fd_sc_hd__decap_8
XFILLER_2_164 VGND VGND VPWR VPWR sky130_fd_sc_hd__fill_2
XFILLER_2_197 VGND VGND VPWR VPWR sky130_fd_sc_hd__decap_3
XTAP_TAPCELL_ROW_88_1039 VGND VPWR sky130_fd_sc_hd__tapvpwrvgnd_1
XFILLER_48_71 VGND VGND VPWR VPWR sky130_fd_sc_hd__decap_6
XTAP_TAPCELL_ROW_64_807 VGND VPWR sky130_fd_sc_hd__tapvpwrvgnd_1
XFILLER_46_363 VGND VGND VPWR VPWR sky130_fd_sc_hd__fill_1
XFILLER_73_193 VGND VGND VPWR VPWR sky130_fd_sc_hd__decap_6
X_2990_ _0663_ _0940_ VGND VGND VPWR VPWR _0943_ sky130_fd_sc_hd__nand2_1
XTAP_TAPCELL_ROW_72_884 VGND VPWR sky130_fd_sc_hd__tapvpwrvgnd_1
X_3611_ _1471_ _1473_ _1474_ VGND VGND VPWR VPWR _1500_ sky130_fd_sc_hd__a21oi_1
X_3542_ net195 net179 _1429_ _1428_ VGND VGND VPWR VPWR _1431_ sky130_fd_sc_hd__a31o_1
X_3473_ systolic_unit_0.U_10.acc_0\[5\] systolic_unit_0.U_00.acc_0\[5\] net207 VGND
+ VGND VPWR VPWR _1384_ sky130_fd_sc_hd__mux2_1
X_2424_ _2081_ _2117_ _2122_ VGND VGND VPWR VPWR _2123_ sky130_fd_sc_hd__nand3_1
XFILLER_69_444 VGND VGND VPWR VPWR sky130_fd_sc_hd__decap_4
XFILLER_69_433 VGND VGND VPWR VPWR sky130_fd_sc_hd__decap_4
X_2355_ net275 net254 net260 net256 VGND VGND VPWR VPWR _2054_ sky130_fd_sc_hd__and4_1
XFILLER_84_414 VGND VGND VPWR VPWR sky130_fd_sc_hd__decap_6
X_2286_ _1982_ _1983_ _1984_ VGND VGND VPWR VPWR _1985_ sky130_fd_sc_hd__or3_1
XFILLER_84_469 VGND VGND VPWR VPWR sky130_fd_sc_hd__decap_6
X_4025_ net240 VGND VGND VPWR VPWR _0006_ sky130_fd_sc_hd__inv_2
XFILLER_37_385 VGND VGND VPWR VPWR sky130_fd_sc_hd__fill_2
XFILLER_25_547 VGND VGND VPWR VPWR sky130_fd_sc_hd__decap_6
XTAP_TAPCELL_ROW_35_531 VGND VPWR sky130_fd_sc_hd__tapvpwrvgnd_1
XFILLER_64_171 VGND VGND VPWR VPWR sky130_fd_sc_hd__decap_8
XFILLER_64_193 VGND VGND VPWR VPWR sky130_fd_sc_hd__decap_3
XFILLER_52_377 VGND VGND VPWR VPWR sky130_fd_sc_hd__decap_4
XFILLER_20_241 VGND VGND VPWR VPWR sky130_fd_sc_hd__decap_3
XFILLER_20_263 VPWR VGND VPWR VGND sky130_ef_sc_hd__decap_12
X_3809_ _1697_ _1696_ VGND VGND VPWR VPWR _1698_ sky130_fd_sc_hd__and2b_1
XFILLER_4_407 VPWR VGND VPWR VGND sky130_ef_sc_hd__decap_12
XFILLER_87_241 VPWR VGND VPWR VGND sky130_ef_sc_hd__decap_12
XTAP_TAPCELL_ROW_7_267 VGND VPWR sky130_fd_sc_hd__tapvpwrvgnd_1
XFILLER_85_69 VPWR VGND VPWR VGND sky130_ef_sc_hd__decap_12
XFILLER_75_447 VGND VGND VPWR VPWR sky130_fd_sc_hd__fill_1
XFILLER_28_341 VPWR VGND VPWR VGND sky130_ef_sc_hd__decap_12
XFILLER_90_428 VPWR VGND VPWR VGND sky130_ef_sc_hd__decap_12
XFILLER_43_333 VGND VGND VPWR VPWR sky130_fd_sc_hd__decap_3
XFILLER_70_141 VPWR VGND VPWR VGND sky130_ef_sc_hd__decap_12
XFILLER_70_174 VGND VGND VPWR VPWR sky130_fd_sc_hd__fill_1
XTAP_TAPCELL_ROW_41_589 VGND VPWR sky130_fd_sc_hd__tapvpwrvgnd_1
XFILLER_50_94 VGND VGND VPWR VPWR sky130_fd_sc_hd__decap_6
XFILLER_3_473 VPWR VGND VPWR VGND sky130_ef_sc_hd__decap_12
XFILLER_78_241 VGND VGND VPWR VPWR sky130_fd_sc_hd__fill_1
XTAP_TAPCELL_ROW_77_932 VGND VPWR sky130_fd_sc_hd__tapvpwrvgnd_1
X_2140_ systolic_unit_0.out_acc_0_r1\[14\] systolic_unit_0.out_acc_1_r1\[14\] net143
+ VGND VGND VPWR VPWR _1870_ sky130_fd_sc_hd__mux2_1
XFILLER_93_244 VGND VGND VPWR VPWR sky130_fd_sc_hd__decap_4
XTAP_TAPCELL_ROW_49_667 VGND VPWR sky130_fd_sc_hd__tapvpwrvgnd_1
XFILLER_66_469 VGND VGND VPWR VPWR sky130_fd_sc_hd__fill_1
XFILLER_93_277 VGND VGND VPWR VPWR sky130_fd_sc_hd__decap_3
X_2973_ _0923_ _0924_ _0869_ VGND VGND VPWR VPWR _0926_ sky130_fd_sc_hd__a21o_1
XTAP_TAPCELL_ROW_32_501 VGND VPWR sky130_fd_sc_hd__tapvpwrvgnd_1
XFILLER_34_399 VPWR VGND VPWR VGND sky130_ef_sc_hd__decap_12
X_3525_ net137 _1389_ VGND VGND VPWR VPWR _1418_ sky130_fd_sc_hd__nor2_1
XFILLER_89_517 VPWR VGND VPWR VGND sky130_ef_sc_hd__decap_12
X_3456_ systolic_unit_0.U_10.acc_0\[9\] systolic_unit_0.U_00.acc_0\[9\] net206 VGND
+ VGND VPWR VPWR _1371_ sky130_fd_sc_hd__mux2_1
XFILLER_69_241 VGND VGND VPWR VPWR sky130_fd_sc_hd__decap_3
X_3387_ _1305_ _1306_ _1307_ VGND VGND VPWR VPWR _1308_ sky130_fd_sc_hd__and3_1
X_2407_ _2071_ _2074_ _2102_ _2105_ VGND VGND VPWR VPWR _2106_ sky130_fd_sc_hd__o211a_1
X_2338_ _2008_ _2012_ _2011_ VGND VGND VPWR VPWR _2037_ sky130_fd_sc_hd__a21o_1
XFILLER_69_263 VPWR VGND VPWR VGND sky130_ef_sc_hd__decap_12
XTAP_TAPCELL_ROW_4_237 VGND VPWR sky130_fd_sc_hd__tapvpwrvgnd_1
X_2269_ net263 net216 net214 net264 VGND VGND VPWR VPWR _1968_ sky130_fd_sc_hd__a22o_1
X_4008_ matrix_count\[0\] net35 VGND VGND VPWR VPWR _1857_ sky130_fd_sc_hd__or2_1
XFILLER_13_517 VPWR VGND VPWR VGND sky130_ef_sc_hd__decap_12
XFILLER_80_494 VPWR VGND VPWR VGND sky130_ef_sc_hd__decap_12
XFILLER_52_174 VGND VGND VPWR VPWR sky130_fd_sc_hd__fill_1
XFILLER_4_248 VGND VGND VPWR VPWR sky130_fd_sc_hd__decap_4
XFILLER_0_410 VGND VGND VPWR VPWR sky130_fd_sc_hd__decap_8
XFILLER_0_421 VPWR VGND VPWR VGND sky130_ef_sc_hd__decap_12
Xhold40 systolic_unit_0.U_10.acc_0\[7\] VGND VGND VPWR VPWR net315 sky130_fd_sc_hd__dlygate4sd3_1
XFILLER_75_233 VGND VGND VPWR VPWR sky130_fd_sc_hd__decap_3
Xhold62 net69 VGND VGND VPWR VPWR net337 sky130_fd_sc_hd__dlygate4sd3_1
Xhold51 systolic_unit_0.U_10.acc_0\[4\] VGND VGND VPWR VPWR net326 sky130_fd_sc_hd__dlygate4sd3_1
Xhold73 net57 VGND VGND VPWR VPWR net348 sky130_fd_sc_hd__dlygate4sd3_1
XTAP_TAPCELL_ROW_85_1009 VGND VPWR sky130_fd_sc_hd__tapvpwrvgnd_1
XFILLER_75_288 VGND VGND VPWR VPWR sky130_fd_sc_hd__fill_1
XFILLER_75_277 VGND VGND VPWR VPWR sky130_fd_sc_hd__decap_3
XTAP_TAPCELL_ROW_74_902 VGND VPWR sky130_fd_sc_hd__tapvpwrvgnd_1
Xhold84 systolic_unit_0.U_00.acc_1\[0\] VGND VGND VPWR VPWR net359 sky130_fd_sc_hd__dlygate4sd3_1
Xhold95 systolic_unit_0.U_00.acc_0\[12\] VGND VGND VPWR VPWR net370 sky130_fd_sc_hd__dlygate4sd3_1
XFILLER_28_160 VPWR VGND VPWR VGND sky130_ef_sc_hd__decap_12
XTAP_TAPCELL_ROW_46_637 VGND VPWR sky130_fd_sc_hd__tapvpwrvgnd_1
XFILLER_45_72 VGND VGND VPWR VPWR sky130_fd_sc_hd__decap_4
XFILLER_31_314 VGND VGND VPWR VPWR sky130_fd_sc_hd__decap_3
XFILLER_43_185 VGND VGND VPWR VPWR sky130_fd_sc_hd__fill_1
XANTENNA_4 systolic_unit_0.drain_valid VGND VGND VPWR VPWR sky130_fd_sc_hd__diode_2
X_3310_ net115 net113 net158 net156 VGND VGND VPWR VPWR _1231_ sky130_fd_sc_hd__and4_1
XFILLER_6_77 VGND VGND VPWR VPWR sky130_fd_sc_hd__decap_6
X_4290_ clknet_leaf_24_clk net361 VGND VGND VPWR VPWR row_count\[1\] sky130_fd_sc_hd__dfxtp_1
XFILLER_3_281 VPWR VGND VPWR VGND sky130_ef_sc_hd__decap_12
X_3241_ _1083_ _1088_ VGND VGND VPWR VPWR _1162_ sky130_fd_sc_hd__xnor2_1
X_3172_ net156 net107 net105 net158 VGND VGND VPWR VPWR _1093_ sky130_fd_sc_hd__a22o_1
XFILLER_20_3 VPWR VGND VPWR VGND sky130_ef_sc_hd__decap_12
XFILLER_66_200 VPWR VGND VPWR VGND sky130_ef_sc_hd__decap_12
XTAP_TAPCELL_ROW_1_207 VGND VPWR sky130_fd_sc_hd__tapvpwrvgnd_1
XFILLER_39_447 VGND VGND VPWR VPWR sky130_fd_sc_hd__fill_1
XFILLER_81_203 VPWR VGND VPWR VGND sky130_ef_sc_hd__decap_12
XFILLER_81_225 VGND VGND VPWR VPWR sky130_fd_sc_hd__decap_8
XFILLER_19_193 VGND VGND VPWR VPWR sky130_fd_sc_hd__decap_4
XFILLER_34_141 VGND VGND VPWR VPWR sky130_fd_sc_hd__fill_1
XTAP_TAPCELL_ROW_17_361 VGND VPWR sky130_fd_sc_hd__tapvpwrvgnd_1
XFILLER_22_347 VPWR VGND VPWR VGND sky130_ef_sc_hd__decap_12
X_2956_ net177 net127 _0900_ VGND VGND VPWR VPWR _0909_ sky130_fd_sc_hd__a21oi_1
X_2887_ _0839_ _0822_ VGND VGND VPWR VPWR _0840_ sky130_fd_sc_hd__and2b_1
XFILLER_1_207 VPWR VGND VPWR VGND sky130_ef_sc_hd__decap_12
X_4488_ clknet_leaf_25_clk net313 _0212_ VGND VGND VPWR VPWR systolic_unit_0.out_acc_0_r1\[3\]
+ sky130_fd_sc_hd__dfrtp_1
X_3508_ net305 net76 net83 net378 _1409_ VGND VGND VPWR VPWR _0301_ sky130_fd_sc_hd__a221o_1
X_3439_ _1058_ _1060_ VGND VGND VPWR VPWR _1358_ sky130_fd_sc_hd__nand2_1
XFILLER_66_27 VGND VGND VPWR VPWR sky130_fd_sc_hd__fill_1
XFILLER_85_553 VGND VGND VPWR VPWR sky130_fd_sc_hd__fill_1
XFILLER_66_38 VGND VGND VPWR VPWR sky130_fd_sc_hd__fill_2
XFILLER_45_439 VGND VGND VPWR VPWR sky130_fd_sc_hd__decap_8
XFILLER_57_288 VGND VGND VPWR VPWR sky130_fd_sc_hd__fill_1
XFILLER_82_15 VPWR VGND VPWR VGND sky130_ef_sc_hd__decap_12
XTAP_TAPCELL_ROW_43_607 VGND VPWR sky130_fd_sc_hd__tapvpwrvgnd_1
XTAP_TAPCELL_ROW_51_684 VGND VPWR sky130_fd_sc_hd__tapvpwrvgnd_1
XFILLER_31_41 VGND VGND VPWR VPWR sky130_fd_sc_hd__fill_1
Xoutput52 net52 VGND VGND VPWR VPWR D_c_flat[21] sky130_fd_sc_hd__buf_2
Xoutput41 net41 VGND VGND VPWR VPWR D_c_flat[11] sky130_fd_sc_hd__buf_2
XTAP_TAPCELL_ROW_91_1068 VGND VPWR sky130_fd_sc_hd__tapvpwrvgnd_1
Xoutput63 net63 VGND VGND VPWR VPWR D_c_flat[31] sky130_fd_sc_hd__buf_2
XFILLER_76_553 VGND VGND VPWR VPWR sky130_fd_sc_hd__fill_1
XFILLER_76_520 VPWR VGND VPWR VGND sky130_ef_sc_hd__decap_12
XFILLER_36_417 VGND VGND VPWR VPWR sky130_fd_sc_hd__decap_3
XFILLER_48_277 VGND VGND VPWR VPWR sky130_fd_sc_hd__fill_1
XTAP_TAPCELL_ROW_59_762 VGND VPWR sky130_fd_sc_hd__tapvpwrvgnd_1
XFILLER_63_225 VGND VGND VPWR VPWR sky130_fd_sc_hd__decap_8
XFILLER_16_152 VGND VGND VPWR VPWR sky130_fd_sc_hd__decap_3
XTAP_TAPCELL_ROW_14_331 VGND VPWR sky130_fd_sc_hd__tapvpwrvgnd_1
X_2810_ net176 net118 _0720_ VGND VGND VPWR VPWR _0763_ sky130_fd_sc_hd__a21oi_1
X_3790_ _1672_ _1678_ VGND VGND VPWR VPWR _1679_ sky130_fd_sc_hd__nand2_1
X_2741_ _0666_ _0680_ _0692_ VGND VGND VPWR VPWR _0694_ sky130_fd_sc_hd__nand3_1
XFILLER_8_362 VGND VGND VPWR VPWR sky130_fd_sc_hd__fill_2
X_2672_ _0620_ _0621_ _0623_ VGND VGND VPWR VPWR _0625_ sky130_fd_sc_hd__or3_1
XFILLER_8_395 VPWR VGND VPWR VGND sky130_ef_sc_hd__decap_12
X_4411_ clknet_leaf_6_clk _0376_ _0135_ VGND VGND VPWR VPWR systolic_unit_0.U_00.acc_0\[7\]
+ sky130_fd_sc_hd__dfrtp_1
X_4342_ clknet_leaf_25_clk net112 _0066_ VGND VGND VPWR VPWR systolic_unit_0.U_10.out_a\[2\]
+ sky130_fd_sc_hd__dfrtp_1
X_4273_ clknet_leaf_17_clk _0254_ _0009_ VGND VGND VPWR VPWR systolic_unit_0.U_11.acc_1\[9\]
+ sky130_fd_sc_hd__dfrtp_1
X_3224_ _1142_ _1143_ _1141_ VGND VGND VPWR VPWR _1145_ sky130_fd_sc_hd__a21boi_1
.ends
